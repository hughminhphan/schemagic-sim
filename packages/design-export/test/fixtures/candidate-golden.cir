scheMAGIC Simulator document 0461b23be7b014af
* scheMAGIC Designer candidate export
* candidate-id candidate:golden
* recipe-id power.synthetic.golden
* request-hash fnv1a64:golden-request
* analysis-mode op
* model-boundary Circuit behavior follows the candidate's declared simulation coverage; selected BOM identity does not imply a physical SPICE model.
* candidate-warning Alpha warning
* candidate-warning Zulu warning
* coverage startup | unavailable | No startup model is attached
* coverage steady_state | behavioral | Generic source behavior only
* document-hash 0461b23be7b014af
V1 n1 0 DC 5 $ component:c1
.save all v1#branch
.op
.end
