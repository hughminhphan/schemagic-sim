OpenCircuit factory test: DOZ30N03 RDS(on)
* OpenCircuit Model Factory v0.1.0 bulk adapter
* Original work generated from public factual specifications.
* This model is not copied or adapted from any vendor SPICE model.
* Source: https://jlcpcb.com/api/file/downloadByFileSystemAccessId/8604416394641756160
* Revision: Not stated in the public PDF
.model OC_DOINGTER_DOZ30N03 VDMOS( VTO=1.5000000000e0 KP=2.0000000000e2 THETA=0.0000000000e0 LAMBDA=3.0000000000e-3 RD=5.5000000000e-3 RS=2.0000000000e-3 RG=1.0000000000e-4 RDS=1e9 CGS=4.5500000000e-10 CGDMAX=9.5000000000e-11 CGDMIN=9.5000000000e-11 CJO=1.0000000000e-11 IS=1.0000000000e-12 N=1.5000000000e0 RB=2.0000000000e-3)

.temp 25
M1 d1 g1 0 OC_DOINGTER_DOZ30N03
ID1 0 d1 DC 1.0000000000e1
VG1 g1 0 DC 1.0000000000e1
.op
.end
