* OpenCircuit Model Factory v0.1.0 bulk adapter
* Original work generated from public factual specifications.
* This model is not copied or adapted from any vendor SPICE model.
* Source: https://jlcpcb.com/api/file/downloadByFileSystemAccessId/8604416409044590592
* Revision: Revision not stated; document dated 2019-07-12
.model OC_DOINGTER_DOD20N06 VDMOS( VTO=1.6000000000e0 KP=7.6923076923e1 THETA=0.0000000000e0 LAMBDA=3.0000000000e-3 RD=1.4300000000e-2 RS=5.2000000000e-3 RG=1.0000000000e-4 RDS=1e9 CGS=1.1047000000e-9 CGDMAX=4.5300000000e-11 CGDMIN=4.5300000000e-11 CJO=9.7000000000e-12 IS=1.0000000000e-12 N=1.5000000000e0 RB=5.2000000000e-3)
