* OpenCircuit Model Factory v0.1.0 bulk adapter
* Original work generated from public factual specifications.
* This model is not copied or adapted from any vendor SPICE model.
* Source: https://jlcpcb.com/api/file/downloadByFileSystemAccessId/8604443993917321216
* Revision: No revision code printed; PDF created 2021-03-16 (WPS), 4 pages, www.doingter.cn
.model OC_DOINGTER_DO2302E-Q VDMOS( VTO=7.0000000000e-1 KP=4.4444444444e1 THETA=0.0000000000e0 LAMBDA=3.0000000000e-3 RD=2.4750000000e-2 RS=9.0000000000e-3 RG=1.0000000000e-4 RDS=1e9 CGS=1.5500000000e-10 CGDMAX=2.5000000000e-11 CGDMIN=2.5000000000e-11 CJO=1.0000000000e-11 IS=1.0000000000e-12 N=1.5000000000e0 RB=9.0000000000e-3)
