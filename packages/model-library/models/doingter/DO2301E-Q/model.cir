* OpenCircuit Model Factory v0.1.0 bulk adapter
* Original work generated from public factual specifications.
* This model is not copied or adapted from any vendor SPICE model.
* Source: https://jlcpcb.com/api/file/downloadByFileSystemAccessId/8556937312011132928
* Revision: not stated in PDF
.model OC_DOINGTER_DO2301E-Q VDMOS( pchan VTO=-7.0000000000e-1 KP=2.1052631579e1 THETA=0.0000000000e0 LAMBDA=3.0000000000e-3 RD=5.2250000000e-2 RS=1.9000000000e-2 RG=1.0000000000e-4 RDS=1e9 CGS=1.2600000000e-10 CGDMAX=2.4000000000e-11 CGDMIN=2.4000000000e-11 CJO=1.0000000000e-11 IS=1.0000000000e-12 N=1.5000000000e0 RB=1.9000000000e-2)
