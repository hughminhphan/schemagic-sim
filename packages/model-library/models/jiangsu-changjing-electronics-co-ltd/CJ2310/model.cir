* OpenCircuit Model Factory v0.1.0 bulk adapter
* Original work generated from public factual specifications.
* This model is not copied or adapted from any vendor SPICE model.
* Source: https://jlcpcb.com/api/file/downloadByFileSystemAccessId/8586175307544211456
* Revision: E, Apr 2015
.model OC_JIANGSU-CHANGJING-ELECTRONICS-TECHNOLOGY-CO-LTD_CJ2310 VDMOS( VTO=2.0000000000e0 KP=1.9047619048e1 THETA=0.0000000000e0 LAMBDA=3.0000000000e-3 RD=5.7750000000e-2 RS=2.1000000000e-2 RG=1.0000000000e-4 RDS=1e9 CGS=2.2750000000e-10 CGDMAX=1.9500000000e-11 CGDMIN=1.9500000000e-11 CJO=1.4500000000e-11 IS=1.0000000000e-12 N=1.5000000000e0 RB=2.1000000000e-2)
