OpenCircuit factory test: CJE3134K RDS(on)
* OpenCircuit Model Factory v0.1.0 bulk adapter
* Original work generated from public factual specifications.
* This model is not copied or adapted from any vendor SPICE model.
* Source: https://jlcpcb.com/api/file/downloadByFileSystemAccessId/8588912679817777152
* Revision: Rev. - 1.0
.model OC_JIANGSU-CHANGJING-ELECTRONICS-TECHNOLOGY-CO-LTD_CJE3134K VDMOS( VTO=1.1000000000e0 KP=5.2631578947e0 THETA=0.0000000000e0 LAMBDA=3.0000000000e-3 RD=2.0900000000e-1 RS=7.6000000000e-2 RG=1.0000000000e-4 RDS=1e9 CGS=1.0500000000e-10 CGDMAX=1.5000000000e-11 CGDMIN=1.5000000000e-11 CJO=5.0000000000e-12 IS=1.0000000000e-12 N=1.5000000000e0 RB=7.6000000000e-2)

.temp 25
M1 d1 g1 0 OC_JIANGSU-CHANGJING-ELECTRONICS-TECHNOLOGY-CO-LTD_CJE3134K
ID1 0 d1 DC 6.5000000000e-1
VG1 g1 0 DC 4.5000000000e0
M2 d2 g2 0 OC_JIANGSU-CHANGJING-ELECTRONICS-TECHNOLOGY-CO-LTD_CJE3134K
ID2 0 d2 DC 5.5000000000e-1
VG2 g2 0 DC 2.5000000000e0
M3 d3 g3 0 OC_JIANGSU-CHANGJING-ELECTRONICS-TECHNOLOGY-CO-LTD_CJE3134K
ID3 0 d3 DC 4.5000000000e-1
VG3 g3 0 DC 1.8000000000e0
.op
.end
