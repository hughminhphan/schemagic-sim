OpenCircuit factory test: BCX53-16-RANGE-100-250 DC gain
* OpenCircuit Model Factory v0.1.0 bulk adapter
* Original work generated from public factual specifications.
* This model is not copied or adapted from any vendor SPICE model.
* Source: https://jlcpcb.com/api/file/downloadByFileSystemAccessId/8586172158997909504
* Revision: E, Nov 2015
.model OC_JIANGSU-CHANGJING-ELECTRONICS-TECHNOLOGY-CO-LTD_BCX53-16-RANGE-100-250 PNP(IS=1.0000000000e-14 BF=2.4366022387e2 VAF=1.0000000000e2 IKF=1.7800324296e-1 ISE=2.4544726460e-14 NE=1.5000000000e0 NF=1.0000000000e0 RB=1.0000000000e1 RC=1.0000000000e-1 RE=5.0000000000e-2 CJE=1.0000000000e-12 CJC=1.0000000000e-12 TF=1.0000000000e-9)

.temp 25
VCG1 cg1 0 DC -2.0000000000e0
IBG1 0 bg1 DC -4.5454545455e-6
QG1 cg1 bg1 0 OC_JIANGSU-CHANGJING-ELECTRONICS-TECHNOLOGY-CO-LTD_BCX53-16-RANGE-100-250
VCG2 cg2 0 DC -2.0000000000e0
IBG2 0 bg2 DC -4.7619047619e-5
QG2 cg2 bg2 0 OC_JIANGSU-CHANGJING-ELECTRONICS-TECHNOLOGY-CO-LTD_BCX53-16-RANGE-100-250
VCG3 cg3 0 DC -2.0000000000e0
IBG3 0 bg3 DC -5.8823529412e-4
QG3 cg3 bg3 0 OC_JIANGSU-CHANGJING-ELECTRONICS-TECHNOLOGY-CO-LTD_BCX53-16-RANGE-100-250
VCG4 cg4 0 DC -2.0000000000e0
IBG4 0 bg4 DC -2.8571428571e-2
QG4 cg4 bg4 0 OC_JIANGSU-CHANGJING-ELECTRONICS-TECHNOLOGY-CO-LTD_BCX53-16-RANGE-100-250
VCG5 cg5 0 DC -2.0000000000e0
IBG5 0 bg5 DC -7.9365079365e-5
QG5 cg5 bg5 0 OC_JIANGSU-CHANGJING-ELECTRONICS-TECHNOLOGY-CO-LTD_BCX53-16-RANGE-100-250
VCG6 cg6 0 DC -2.0000000000e0
IBG6 0 bg6 DC -1.5000000000e-3
QG6 cg6 bg6 0 OC_JIANGSU-CHANGJING-ELECTRONICS-TECHNOLOGY-CO-LTD_BCX53-16-RANGE-100-250
VCG7 cg7 0 DC -2.0000000000e0
IBG7 0 bg7 DC -6.0000000000e-4
QG7 cg7 bg7 0 OC_JIANGSU-CHANGJING-ELECTRONICS-TECHNOLOGY-CO-LTD_BCX53-16-RANGE-100-250
VCG8 cg8 0 DC -2.0000000000e0
IBG8 0 bg8 DC -1.2500000000e-2
QG8 cg8 bg8 0 OC_JIANGSU-CHANGJING-ELECTRONICS-TECHNOLOGY-CO-LTD_BCX53-16-RANGE-100-250
.op
.end
