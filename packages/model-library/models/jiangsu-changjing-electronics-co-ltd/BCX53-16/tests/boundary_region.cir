OpenCircuit factory test: BCX53-16-RANGE-100-250 supported-region upper-current boundary
* OpenCircuit Model Factory v0.1.0 bulk adapter
* Original work generated from public factual specifications.
* This model is not copied or adapted from any vendor SPICE model.
* Source: https://jlcpcb.com/api/file/downloadByFileSystemAccessId/8586172158997909504
* Revision: E, Nov 2015
.model OC_JIANGSU-CHANGJING-ELECTRONICS-TECHNOLOGY-CO-LTD_BCX53-16-RANGE-100-250 PNP(IS=1.0000000000e-14 BF=2.4366022387e2 VAF=1.0000000000e2 IKF=1.7800324296e-1 ISE=2.4544726460e-14 NE=1.5000000000e0 NF=1.0000000000e0 RB=1.0000000000e1 RC=1.0000000000e-1 RE=5.0000000000e-2 CJE=1.0000000000e-12 CJC=1.0000000000e-12 TF=1.0000000000e-9)

.temp 25
IC 0 c DC -1.0000000000e0
IB 0 b DC -2.8571428571e-2
Q1 c b 0 OC_JIANGSU-CHANGJING-ELECTRONICS-TECHNOLOGY-CO-LTD_BCX53-16-RANGE-100-250
.op
.end
