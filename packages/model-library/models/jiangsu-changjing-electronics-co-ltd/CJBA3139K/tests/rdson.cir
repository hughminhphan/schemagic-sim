OpenCircuit factory test: CJBA3139K RDS(on)
* OpenCircuit Model Factory v0.1.0 bulk adapter
* Original work generated from public factual specifications.
* This model is not copied or adapted from any vendor SPICE model.
* Source: https://jlcpcb.com/api/file/downloadByFileSystemAccessId/8588912792803397632
* Revision: Rev. - 1.0
.model OC_JIANGSU-CHANGJING-ELECTRONICS-TECHNOLOGY-CO-LTD_CJBA3139K VDMOS( pchan VTO=-6.1000000000e-1 KP=3.8461538462e0 THETA=0.0000000000e0 LAMBDA=3.0000000000e-3 RD=2.8600000000e-1 RS=1.0400000000e-1 RG=1.0000000000e-4 RDS=1e9 CGS=1.0400000000e-10 CGDMAX=9.0000000000e-12 CGDMIN=9.0000000000e-12 CJO=6.0000000000e-12 IS=1.0000000000e-12 N=1.5000000000e0 RB=1.0400000000e-1)

.temp 25
M1 d1 g1 0 OC_JIANGSU-CHANGJING-ELECTRONICS-TECHNOLOGY-CO-LTD_CJBA3139K
ID1 d1 0 DC 1.0000000000e0
VG1 g1 0 DC -4.5000000000e0
.op
.end
