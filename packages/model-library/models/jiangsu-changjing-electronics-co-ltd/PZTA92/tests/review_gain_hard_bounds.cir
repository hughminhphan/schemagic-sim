Batch 9 independent review: PZTA92 exact gain hard bounds
* Public datasheet facts only; no vendor SPICE model used.
.model OC_JIANGSU-CHANGJING-ELECTRONICS-TECHNOLOGY-CO-LTD_PZTA92 PNP(IS=1.0000000000e-14 BF=4.0000000000e1 VAF=1.0000000000e2 IKF=1.0000000000e3 RB=1.0000000000e1 RC=1.0000000000e-1 RE=5.0000000000e-2 CJE=1.0000000000e-12 CJC=1.0000000000e-12 TF=1.0000000000e-9)

.temp 25
VCG1 cg1 0 DC -10
IBG1 0 bg1 DC -2.28637432307436e-05
QG1 cg1 bg1 0 OC_JIANGSU-CHANGJING-ELECTRONICS-TECHNOLOGY-CO-LTD_PZTA92
VCG2 cg2 0 DC -10
IBG2 0 bg2 DC -0.00022876604957283199
QG2 cg2 bg2 0 OC_JIANGSU-CHANGJING-ELECTRONICS-TECHNOLOGY-CO-LTD_PZTA92
VCG3 cg3 0 DC -10
IBG3 0 bg3 DC -0.00068650708638602902
QG3 cg3 bg3 0 OC_JIANGSU-CHANGJING-ELECTRONICS-TECHNOLOGY-CO-LTD_PZTA92
.op
.end
