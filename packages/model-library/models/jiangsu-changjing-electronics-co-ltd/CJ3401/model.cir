* OpenCircuit Model Factory v0.1.0 bulk adapter
* Original work generated from public factual specifications.
* This model is not copied or adapted from any vendor SPICE model.
* Source: https://jlcpcb.com/api/file/downloadByFileSystemAccessId/8586173150958923776
* Revision: A, Dec 2010
.model OC_JIANGSU-CHANGJING-ELECTRONICS-TECHNOLOGY-CO-LTD_CJ3401 VDMOS( pchan VTO=-7.0000000000e-1 KP=3.0769230769e1 THETA=0.0000000000e0 LAMBDA=3.0000000000e-3 RD=3.5750000000e-2 RS=1.3000000000e-2 RG=1.0000000000e-4 RDS=1e9 CGS=8.7700000000e-10 CGDMAX=7.7000000000e-11 CGDMIN=7.7000000000e-11 CJO=3.8000000000e-11 IS=1.0000000000e-12 N=1.5000000000e0 RB=1.3000000000e-2)
