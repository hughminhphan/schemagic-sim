OpenCircuit independent F2 residual probe
* OpenCircuit Model Factory v0.1.0 bulk adapter
* Original work generated from public factual specifications.
* This model is not copied or adapted from any vendor SPICE model.
* Source: https://jlcpcb.com/api/file/downloadByFileSystemAccessId/8586202711444901888
* Revision: H, Aug 2015
.model OC_JIANGSU-CHANGJING-ELECTRONICS-TECHNOLOGY-CO-LTD_CJ3139K VDMOS( pchan VTO=-5.9765005928e-1 KP=2.0494395946e0 THETA=4.7065177537e-1 LAMBDA=2.0537772920e-2 RD=1.0026708209e-6 RS=8.6000000000e-2 RG=1.0000000000e-4 RDS=1e9 CGS=1.0400000000e-10 CGDMAX=9.0000000000e-12 CGDMIN=9.0000000000e-12 CJO=6.0000000000e-12 IS=1.0000000000e-12 N=1.5000000000e0 RB=8.6000000000e-2)
.temp 25
M1 d g 0 OC_JIANGSU-CHANGJING-ELECTRONICS-TECHNOLOGY-CO-LTD_CJ3139K
VD d 0 DC -3
VG g 0 DC -1.5
.op
.end
