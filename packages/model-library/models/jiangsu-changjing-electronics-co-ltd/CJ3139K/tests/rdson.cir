OpenCircuit factory test: CJ3139K RDS(on)
* OpenCircuit Model Factory v0.1.0 bulk adapter
* Original work generated from public factual specifications.
* This model is not copied or adapted from any vendor SPICE model.
* Source: https://jlcpcb.com/api/file/downloadByFileSystemAccessId/8586202711444901888
* Revision: H, Aug 2015
.model OC_JIANGSU-CHANGJING-ELECTRONICS-TECHNOLOGY-CO-LTD_CJ3139K VDMOS( pchan VTO=-5.9765005928e-1 KP=2.0494395946e0 THETA=4.7065177537e-1 LAMBDA=2.0537772920e-2 RD=1.0026708209e-6 RS=8.6000000000e-2 RG=1.0000000000e-4 RDS=1e9 CGS=1.0400000000e-10 CGDMAX=9.0000000000e-12 CGDMIN=9.0000000000e-12 CJO=6.0000000000e-12 IS=1.0000000000e-12 N=1.5000000000e0 RB=8.6000000000e-2)

.temp 25
M1 d1 g1 0 OC_JIANGSU-CHANGJING-ELECTRONICS-TECHNOLOGY-CO-LTD_CJ3139K
ID1 d1 0 DC 1.0000000000e0
VG1 g1 0 DC -4.5000000000e0
M2 d2 g2 0 OC_JIANGSU-CHANGJING-ELECTRONICS-TECHNOLOGY-CO-LTD_CJ3139K
ID2 d2 0 DC 8.0000000000e-1
VG2 g2 0 DC -2.5000000000e0
M3 d3 g3 0 OC_JIANGSU-CHANGJING-ELECTRONICS-TECHNOLOGY-CO-LTD_CJ3139K
ID3 d3 0 DC 5.0000000000e-1
VG3 g3 0 DC -1.8000000000e0
.op
.end
