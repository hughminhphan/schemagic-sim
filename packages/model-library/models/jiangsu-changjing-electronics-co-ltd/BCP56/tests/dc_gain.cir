OpenCircuit factory test: BCP56-RANGE-100-250 DC gain
* OpenCircuit Model Factory v0.1.0 bulk adapter
* Original work generated from public factual specifications.
* This model is not copied or adapted from any vendor SPICE model.
* Source: https://jlcpcb.com/api/file/downloadByFileSystemAccessId/8586182546724171776
* Revision: G,Jan,2017
.model OC_JIANGSU-CHANGJING-ELECTRONICS-TECHNOLOGY-CO-LTD_BCP56-RANGE-100-250 NPN(IS=1.0000000000e-14 BF=1.9000000000e2 VAF=1.0000000000e2 IKF=1.0000000000e3 RB=1.0000000000e1 RC=1.0000000000e-1 RE=5.0000000000e-2 CJE=1.0000000000e-12 CJC=1.0000000000e-12 TF=1.0000000000e-9)

.temp 25
VCG1 cg1 0 DC 2.0000000000e0
IBG1 0 bg1 DC 2.0000000000e-4
QG1 cg1 bg1 0 OC_JIANGSU-CHANGJING-ELECTRONICS-TECHNOLOGY-CO-LTD_BCP56-RANGE-100-250
VCG2 cg2 0 DC 2.0000000000e0
IBG2 0 bg2 DC 1.5000000000e-3
QG2 cg2 bg2 0 OC_JIANGSU-CHANGJING-ELECTRONICS-TECHNOLOGY-CO-LTD_BCP56-RANGE-100-250
VCG3 cg3 0 DC 2.0000000000e0
IBG3 0 bg3 DC 2.0000000000e-2
QG3 cg3 bg3 0 OC_JIANGSU-CHANGJING-ELECTRONICS-TECHNOLOGY-CO-LTD_BCP56-RANGE-100-250
VCG4 cg4 0 DC 2.0000000000e0
IBG4 0 bg4 DC 5.2631578947e-4
QG4 cg4 bg4 0 OC_JIANGSU-CHANGJING-ELECTRONICS-TECHNOLOGY-CO-LTD_BCP56-RANGE-100-250
.op
.end
