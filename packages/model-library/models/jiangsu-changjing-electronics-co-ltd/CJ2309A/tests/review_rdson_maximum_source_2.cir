OpenCircuit independent review hard-bound probe
* OpenCircuit Model Factory v0.1.0 bulk adapter
* Original work generated from public factual specifications.
* This model is not copied or adapted from any vendor SPICE model.
* Source: https://jlcpcb.com/api/file/downloadByFileSystemAccessId/8590905844702277632
* Revision: Rev. - 1.2
.model OC_JIANGSU-CHANGJING-ELECTRONICS-TECHNOLOGY-CO-LTD_CJ2309A VDMOS( pchan VTO=-1.9000000000e0 KP=1.5384615385e1 THETA=0.0000000000e0 LAMBDA=3.0000000000e-3 RD=7.1500000000e-2 RS=2.6000000000e-2 RG=1.0000000000e-4 RDS=1e9 CGS=3.7400000000e-10 CGDMAX=6.0000000000e-12 CGDMIN=6.0000000000e-12 CJO=2.6000000000e-11 IS=1.0000000000e-12 N=1.5000000000e0 RB=2.6000000000e-2)
.temp 25
M1 d g 0 OC_JIANGSU-CHANGJING-ELECTRONICS-TECHNOLOGY-CO-LTD_CJ2309A
ID d 0 DC 2.0
VG g 0 DC -10.0
.op
.end
