* OpenCircuit Model Factory v0.1.0
* Original work generated from public factual specifications.
* This model is not a copy of, or adaptation from, any vendor SPICE model.
* IR333A (everlight), datasheet-fitted at 25 degC
* Archetype: archetype-diode.md, variant L
* Node order: D<ref> anode cathode OC_EVERLIGHT_IR333A
.model OC_EVERLIGHT_IR333A D(IS=4.0664618636e-10 N=2.5700369281e+00 RS=1.1633498638e+00 EG=1.3189807766e+00 TNOM=2.5000000000e+01)
