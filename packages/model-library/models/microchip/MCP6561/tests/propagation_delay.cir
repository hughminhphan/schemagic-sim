OpenCircuit factory test: MCP6561 propagation_delay.cir
* Source: https://ww1.microchip.com/downloads/en/DeviceDoc/22139C.pdf
* Revision: DS22139C, 2013
* Fit date: 2026-08-07
* OpenCircuit Model Factory v0.1.0
* Original work generated from public factual specifications.
* This model is not a copy of, or adaptation from, any vendor SPICE model.
* Archetype: docs/model-archetypes/archetype-comparator.md, variant PP
* Node order: INP INN OUT VCC GND
.subckt OC_MICROCHIP_MCP6561 INP INN OUT VCC GND
.param AOL=1.0000000000e+05 VOS=3.0000000000e-03 IBIAS=1.0000000000e-12 IOS=1.0000000000e-12 TPD=3.8739918917e-08
.param ROUT=7.0000000000e+01 ILIM=3.0000000000e-02 VDRP_H=1.2612910777e-01 VDRP_L=2.6129108313e-02
.param VCLAMP=1 KSW=20 VHYST=1.5000000000e-03 IQ=1.0000000000e-04 CD=10p
IBP GND INP DC {IBIAS+IOS/2}
IBN GND INN DC {IBIAS-IOS/2}
CDIF INP INN 1p
BC c GND V = VCLAMP*tanh((AOL/VCLAMP)*(v(INP,INN)+VOS+VHYST*v(cd)/VCLAMP))
RC c cd {TPD/0.693/CD}
CC cd GND {CD}
BQ q GND V = VDRP_L + (v(VCC,GND)-VDRP_H-VDRP_L)*0.5*(1+tanh(KSW*v(cd)/VCLAMP))
RQ q GND 1meg
BOUT GND OUT I = ILIM*tanh((v(q)-v(OUT,GND))/(ROUT*ILIM))
IQD VCC GND DC {IQ}
.ends OC_MICROCHIP_MCP6561

.temp 25
VCC vcc 0 5.5
VREF ref 0 2.75
VIN sig 0 PULSE(2.65 2.85 1u 1n 1n 2u 4u)
X1 sig ref out vcc 0 OC_MICROCHIP_MCP6561
RL out ref 10k
CL out 0 25p
.tran 0.2n 5u
.end
