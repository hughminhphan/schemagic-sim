* OpenCircuit Model Factory v0.1.0 bulk adapter
* Original work generated from public factual specifications.
* This model is not copied or adapted from any vendor SPICE model.
* Source: https://jlcpcb.com/api/file/downloadByFileSystemAccessId/8757771037301841920
* Revision: revision not stated in source
.model OC_GOODWORK_S5M D(IS=4.5828512766e-10 N=1.8000000000e0 RS=1.0000000000e-4)
