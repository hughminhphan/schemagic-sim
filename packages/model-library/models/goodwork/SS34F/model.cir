* OpenCircuit Model Factory v0.1.0 bulk adapter
* Original work generated from public factual specifications.
* This model is not copied or adapted from any vendor SPICE model.
* Source: https://jlcpcb.com/api/file/downloadByFileSystemAccessId/8757772768068939776
* Revision: REV 2.0 2025 JAN
.model OC_GOODWORK_SS34F D(IS=1.0596332086e-10 N=1.1000000000e0 RS=1.0000000000e-4)
