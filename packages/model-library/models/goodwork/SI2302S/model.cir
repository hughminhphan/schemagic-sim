* OpenCircuit Model Factory v0.1.0 bulk adapter
* Original work generated from public factual specifications.
* This model is not copied or adapted from any vendor SPICE model.
* Source: https://jlcpcb.com/api/file/downloadByFileSystemAccessId/8603371318016692224
* Revision: REV 1.0 2021 JAN
.model OC_GOODWORK_SI2302S VDMOS( VTO=1.0000000000e0 KP=3.3333333333e1 THETA=0.0000000000e0 LAMBDA=3.0000000000e-3 RD=3.3000000000e-2 RS=1.2000000000e-2 RG=1.0000000000e-4 RDS=1e9 CGS=1.7200000000e-10 CGDMAX=2.8000000000e-11 CGDMIN=2.8000000000e-11 CJO=7.0000000000e-12 IS=1.0000000000e-12 N=1.5000000000e0 RB=1.2000000000e-2)
