OpenCircuit factory test: reverse leakage
* OpenCircuit Model Factory v0.1.0 bulk adapter
* Original work generated from public factual specifications.
* This model is not copied or adapted from any vendor SPICE model.
* Source: https://jlcpcb.com/api/file/downloadByFileSystemAccessId/8757769741031624704
* Revision: Rev. 2.0, 2025 JAN
.model OC_GOODWORK_K14 D(IS=5.4169720038e-5 N=2.0421011845e0 RS=2.0980083961e-2)

.temp 25
Vreverse cathode 0 DC 4.0000000000e1
Ddut 0 cathode OC_GOODWORK_K14
.op
.end
