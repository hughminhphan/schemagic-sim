OpenCircuit independent review hard-bound probe
* OpenCircuit Model Factory v0.1.0 bulk adapter
* Original work generated from public factual specifications.
* This model is not copied or adapted from any vendor SPICE model.
* Source: https://jlcpcb.com/api/file/downloadByFileSystemAccessId/8757767510114746368
* Revision: REV 2.0 2025 JAN
.model OC_GOODWORK_A7 D(IS=6.3567923561e-8 N=2.2501476665e0 RS=1.9018033992e-2)
.temp 25
Vreverse cathode 0 DC 1.000000000000e+03
Ddut 0 cathode OC_GOODWORK_A7
.op
.end
