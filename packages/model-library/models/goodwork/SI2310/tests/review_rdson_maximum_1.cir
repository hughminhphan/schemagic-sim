OpenCircuit independent review hard-bound probe
* OpenCircuit Model Factory v0.1.0 bulk adapter
* Original work generated from public factual specifications.
* This model is not copied or adapted from any vendor SPICE model.
* Source: https://jlcpcb.com/api/file/downloadByFileSystemAccessId/8757962829993926656
* Revision: Rev 2.0, January 2025
.model OC_GOODWORK_SI2310 VDMOS( VTO=1.0300000000e0 KP=2.5641025641e1 THETA=0.0000000000e0 LAMBDA=3.0000000000e-3 RD=4.2900000000e-2 RS=1.5600000000e-2 RG=1.0000000000e-4 RDS=1e9 CGS=2.2750000000e-10 CGDMAX=1.9500000000e-11 CGDMIN=1.9500000000e-11 CJO=1.4500000000e-11 IS=1.0000000000e-12 N=1.5000000000e0 RB=1.5600000000e-2)
.temp 25
M1 d g 0 OC_GOODWORK_SI2310
ID 0 d DC 3.000000000000e+0
VG g 0 DC 1.000000000000e+1
.op
.end
