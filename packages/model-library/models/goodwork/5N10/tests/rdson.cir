OpenCircuit factory test: 5N10 RDS(on)
* OpenCircuit Model Factory v0.1.0 bulk adapter
* Original work generated from public factual specifications.
* This model is not copied or adapted from any vendor SPICE model.
* Source: https://jlcpcb.com/api/file/downloadByFileSystemAccessId/8590904721118863360
* Revision: REV 1.0, 2020 JAN
.model OC_GOODWORK_5N10 VDMOS( VTO=1.8000000000e0 KP=1.8181818182e1 THETA=0.0000000000e0 LAMBDA=3.0000000000e-3 RD=6.0500000000e-2 RS=2.2000000000e-2 RG=1.0000000000e-4 RDS=1e9 CGS=2.0460000000e-10 CGDMAX=1.4000000000e-12 CGDMIN=1.4000000000e-12 CJO=2.7600000000e-11 IS=1.0000000000e-12 N=1.5000000000e0 RB=2.2000000000e-2)

.temp 25
M1 d1 g1 0 OC_GOODWORK_5N10
ID1 0 d1 DC 3.0000000000e0
VG1 g1 0 DC 1.0000000000e1
.op
.end
