* OpenCircuit Model Factory v0.1.0 bulk adapter
* Original work generated from public factual specifications.
* This model is not copied or adapted from any vendor SPICE model.
* Source: https://jlcpcb.com/api/file/downloadByFileSystemAccessId/8757962525277741056
* Revision: REV 2.0 2025 JAN
.model OC_GOODWORK_AO3415 VDMOS( pchan VTO=-5.6000000000e-1 KP=6.6666666667e1 THETA=0.0000000000e0 LAMBDA=3.0000000000e-3 RD=1.6500000000e-2 RS=6.0000000000e-3 RG=1.0000000000e-4 RDS=1e9 CGS=1.2900000000e-9 CGDMAX=1.6000000000e-10 CGDMIN=1.6000000000e-10 CJO=4.5000000000e-11 IS=1.0000000000e-12 N=1.5000000000e0 RB=6.0000000000e-3)
