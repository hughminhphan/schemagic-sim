* OpenCircuit Model Factory v0.1.0
* Original work generated from public factual specifications.
* This model is not a copy of, or adaptation from, any vendor SPICE model.
* Source: https://www.kingbrightusa.com/images/catalog/SPEC/WP7113ID.pdf
* Revision: Spec DSAF0012 / 1101005042 Rev V.14A, 01/08/2026
* Fit: scipy.optimize.least_squares at 25 degC
.model OC_KINGBRIGHT_WP7113ID D(IS=3.2541940998e-10 N=4.1465395920e0 RS=4.8842064299e0)
