* WP7113YD supported-region boundary at 0.03 A
* OpenCircuit Model Factory v0.1.0
* Original work generated from public factual specifications.
* This model is not a copy of, or adaptation from, any vendor SPICE model.
* WP7113YD (kingbright), datasheet-fitted at 25 degC
* Archetype: archetype-diode.md, variant L
* Node order: D<ref> anode cathode OC_KINGBRIGHT_WP7113YD
.model OC_KINGBRIGHT_WP7113YD D(IS=4.2571667668e-19 N=2.0000000000e+00 RS=1.0000000000e-01 EG=2.1014270000e+00)
.temp 25
Itest 0 anode DC 3.0000000000e-02
Vanchor anchor 0 DC 0
Ranchor anchor 0 1G
Ddut anode 0 OC_KINGBRIGHT_WP7113YD
.op
.end
