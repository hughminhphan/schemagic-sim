* WP7113PWC reverse leakage at rated 5 V
* OpenCircuit Model Factory v0.1.0
* Original work generated from public factual specifications.
* This model is not a copy of, or adaptation from, any vendor SPICE model.
* WP7113PWC (kingbright), datasheet-fitted at 25 degC
* Archetype: archetype-diode.md, variant L
* Node order: D<ref> anode cathode OC_KINGBRIGHT_WP7113PWC
.model OC_KINGBRIGHT_WP7113PWC D(IS=2.7479731800e-29 N=2.0000000000e+00 RS=1.0000000000e-01 EG=2.7552042889e+00)
.temp 25
Vreverse cathode 0 DC 5
Ddut 0 cathode OC_KINGBRIGHT_WP7113PWC
.save i(Vreverse) @ddut[id]
.op
.end
