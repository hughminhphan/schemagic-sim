* OpenCircuit Model Factory v0.1.0 bulk adapter
* Original work generated from public factual specifications.
* This model is not copied or adapted from any vendor SPICE model.
* Source: https://jlcpcb.com/api/file/downloadByFileSystemAccessId/8588879991233134592
* Revision: revision not stated in source
.model OC_STMICROELECTRONICS_STTH112A D(IS=1.0319646567e-11 N=1.8000000000e0 RS=1.0000000000e-4)
