OpenCircuit factory test: MMBT2907-2F supported-region upper-current boundary
* OpenCircuit Model Factory v0.1.0 bulk adapter
* Original work generated from public factual specifications.
* This model is not copied or adapted from any vendor SPICE model.
* Source: https://jlcpcb.com/api/file/downloadByFileSystemAccessId/8618863265175269376
* Revision: not stated (no revision code or date printed anywhere in the 3-page TDSEMIC datasheet)
.model OC_TDSEMIC_MMBT2907-2F PNP(IS=1.0000000000e-14 BF=1.0100000000e2 VAF=1.0000000000e2 IKF=1.0000000000e3 RB=1.0000000000e1 RC=1.0000000000e-1 RE=5.0000000000e-2 CJE=1.0000000000e-12 CJC=1.0000000000e-12 TF=1.0000000000e-9)

.temp 25
IC 0 c DC -1.5000000000e-1
IB 0 b DC -1.5000000000e-3
Q1 c b 0 OC_TDSEMIC_MMBT2907-2F
.op
.end
