OpenCircuit factory test: BD139 DC gain
* OpenCircuit Model Factory v0.1.0
* Original work generated from public factual specifications.
* This model is not a copy of, or adaptation from, any vendor SPICE model.
* Source: https://www.onsemi.com/pdf/datasheet/bd139-d.pdf
* Revision: BD139/D Rev. 3, April 2026
* Fit: native ngspice-46 in scipy.optimize.least_squares, diff_step=1e-4
.model OC_ONSEMI_BD139 NPN(IS=1.5052068932e-12 NF=1.0000000000e0 BF=2.3598849859e2 IKF=1.4545930597e-1 ISE=1.2505212650e-12 NE=1.6858183924e0 VAF=6.0000000000e1 BR=2.0000000000e0 RB=8.5696809123e-1 RE=4.3914017298e-2 RC=5.6853259792e-1 CJE=1.0000000000e-15 VJE=7.5000000000e-1 MJE=3.3000000000e-1 CJC=1.0000000000e-15 VJC=7.5000000000e-1 MJC=3.3000000000e-1 XCJC=1.0000000000e0 TF=1.0000000000e-12 TR=0 FC=0.5 EG=1.11 XTI=3 TNOM=27)

.temp 25
VCG1 cg1 0 DC 4.0000000000e0
IBG1 0 bg1 DC 2.0000000000e-4
QG1 cg1 bg1 0 OC_ONSEMI_BD139
VCG2 cg2 0 DC 4.0000000000e0
IBG2 0 bg2 DC 3.7500000000e-3
QG2 cg2 bg2 0 OC_ONSEMI_BD139
VCG3 cg3 0 DC 4.0000000000e0
IBG3 0 bg3 DC 2.0000000000e-2
QG3 cg3 bg3 0 OC_ONSEMI_BD139
.op
.end
