OpenCircuit factory test: BC327-40 DC gain
* OpenCircuit Model Factory v0.1.0
* Original work generated from public factual specifications.
* This model is not a copy of, or adaptation from, any vendor SPICE model.
* Source: https://www.onsemi.com/pub/Collateral/BC327-D.PDF
* Revision: Rev. 2, January 2024
* Fit: native ngspice-46 in scipy.optimize.least_squares, diff_step=1e-4
.model OC_ONSEMI_BC327_40 PNP(IS=6.9633401177e-14 NF=1.0000000000e+00 BF=5.3770531574e+02 IKF=3.0124545975e-01 ISE=3.7004969383e-10 NE=3.9999999982e+00 VAF=1.0000000000e+02 BR=4.0000000000e+00 RB=1.3754494134e+01 RE=1.1496912215e-01 RC=3.5052598774e-01 CJE=1.4203367802e-11 VJE=7.5000000000e-01 MJE=3.3000000000e-01 CJC=2.8891881327e-11 VJC=7.5000000000e-01 MJC=3.3000000000e-01 XCJC=1.0000000000e+00 TF=1.4673775916e-09 TR=0.0000000000e+00 FC=5.0000000000e-01 EG=1.1100000000e+00 XTI=3.0000000000e+00 TNOM=2.7000000000e+01)

.temp 25
VCG1 cg1 0 DC -1.0000000000e0
IBG1 0 bg1 DC -2.0000000000e-6
QG1 cg1 bg1 0 OC_ONSEMI_BC327_40
VCG2 cg2 0 DC -1.0000000000e0
IBG2 0 bg2 DC -1.9230769231e-5
QG2 cg2 bg2 0 OC_ONSEMI_BC327_40
VCG3 cg3 0 DC -1.0000000000e0
IBG3 0 bg3 DC -2.5000000000e-4
QG3 cg3 bg3 0 OC_ONSEMI_BC327_40
VCG4 cg4 0 DC -1.0000000000e0
IBG4 0 bg4 DC -1.1538461538e-3
QG4 cg4 bg4 0 OC_ONSEMI_BC327_40
VCG5 cg5 0 DC -1.0000000000e0
IBG5 0 bg5 DC -2.3809523810e-3
QG5 cg5 bg5 0 OC_ONSEMI_BC327_40
.op
.end
