OpenCircuit factory test: MMBT3906LT1G saturation
* OpenCircuit Model Factory v0.1.0 bulk adapter
* Original work generated from public factual specifications.
* This model is not copied or adapted from any vendor SPICE model.
* Source: https://jlcpcb.com/api/file/downloadByFileSystemAccessId/8586176242927718400
* Revision: December 2013, Rev. 11
.model OC_ONSEMI_MMBT3906LT1G PNP(IS=1.4707904371e-14 BF=3.2249498355e2 VAF=1.0000000000e2 IKF=3.4067331861e-2 ISE=1.4187289251e-13 NE=1.5000000000e0 NF=1.0000000000e0 RB=1.0000000000e1 RC=1.0000000000e-1 RE=5.0000000000e-2 CJE=1.0000000000e-12 CJC=1.0000000000e-12 TF=1.0000000000e-9)

.temp 25
ICS1 0 cs1 DC -1.0000000000e-2
IBS1 0 bs1 DC -1.0000000000e-3
QS1 cs1 bs1 0 OC_ONSEMI_MMBT3906LT1G
ICS2 0 cs2 DC -5.0000000000e-2
IBS2 0 bs2 DC -5.0000000000e-3
QS2 cs2 bs2 0 OC_ONSEMI_MMBT3906LT1G
.op
.end
