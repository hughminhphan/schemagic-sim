OpenCircuit factory test: MMBT3906LT1G supported-region upper-current boundary
* OpenCircuit Model Factory v0.1.0 bulk adapter
* Original work generated from public factual specifications.
* This model is not copied or adapted from any vendor SPICE model.
* Source: https://jlcpcb.com/api/file/downloadByFileSystemAccessId/8586176242927718400
* Revision: December 2013, Rev. 11
.model OC_ONSEMI_MMBT3906LT1G PNP(IS=1.4707904371e-14 BF=3.2249498355e2 VAF=1.0000000000e2 IKF=3.4067331861e-2 ISE=1.4187289251e-13 NE=1.5000000000e0 NF=1.0000000000e0 RB=1.0000000000e1 RC=1.0000000000e-1 RE=5.0000000000e-2 CJE=1.0000000000e-12 CJC=1.0000000000e-12 TF=1.0000000000e-9)

.temp 25
IC 0 c DC -1.0000000000e-1
IB 0 b DC -1.5384615385e-3
Q1 c b 0 OC_ONSEMI_MMBT3906LT1G
.op
.end
