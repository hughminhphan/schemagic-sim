* OpenCircuit Model Factory v0.1.0 bulk adapter
* Original work generated from public factual specifications.
* This model is not copied or adapted from any vendor SPICE model.
* Source: https://jlcpcb.com/api/file/downloadByFileSystemAccessId/8586175325227397120
* Revision: Rev.D2, July 2014
.model OC_ONSEMI_FDV303N VDMOS( VTO=8.0000000000e-1 KP=4.4444444444e0 THETA=0.0000000000e0 LAMBDA=3.0000000000e-3 RD=2.4750000000e-1 RS=9.0000000000e-2 RG=1.0000000000e-4 RDS=1e9 CGS=4.1000000000e-11 CGDMAX=9.0000000000e-12 CGDMIN=9.0000000000e-12 CJO=1.9000000000e-11 IS=1.0000000000e-12 N=1.5000000000e0 RB=9.0000000000e-2)
