OpenCircuit factory test: forward_01.cir
* OpenCircuit Model Factory v0.1.0 bulk adapter
* Original work generated from public factual specifications.
* This model is not copied or adapted from any vendor SPICE model.
* Source: https://jlcpcb.com/api/file/downloadByFileSystemAccessId/8586177064903061504
* Revision: October 2016 - Rev. 12
.model OC_ONSEMI_BAV99LT1G D(IS=2.1230509702e-7 N=1.8000000000e0 RS=1.0000000000e-4)

.temp 25
Itest 0 anode DC 1.4250000000e-1
Vanchor anchor 0 DC 0
Ranchor anchor 0 1G
Ddut anode 0 OC_ONSEMI_BAV99LT1G
.op
.end
