OpenCircuit factory test: MMBTA42LT1G supported-region upper-current boundary
* OpenCircuit Model Factory v0.1.0 bulk adapter
* Original work generated from public factual specifications.
* This model is not copied or adapted from any vendor SPICE model.
* Source: https://jlcpcb.com/api/file/downloadByFileSystemAccessId/8586178752703844352
* Revision: Rev. 13, October 2016
.model OC_ONSEMI_MMBTA42LT1G NPN(IS=1.0000000000e-14 BF=9.5000000000e1 VAF=1.0000000000e2 IKF=1.0000000000e3 RB=1.0000000000e1 RC=1.0000000000e-1 RE=5.0000000000e-2 CJE=1.0000000000e-12 CJC=1.0000000000e-12 TF=1.0000000000e-9)

.temp 25
IC 0 c DC 3.0000000000e-2
IB 0 b DC 7.5000000000e-4
Q1 c b 0 OC_ONSEMI_MMBTA42LT1G
.op
.end
