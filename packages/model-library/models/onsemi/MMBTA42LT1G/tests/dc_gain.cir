OpenCircuit factory test: MMBTA42LT1G DC gain
* OpenCircuit Model Factory v0.1.0 bulk adapter
* Original work generated from public factual specifications.
* This model is not copied or adapted from any vendor SPICE model.
* Source: https://jlcpcb.com/api/file/downloadByFileSystemAccessId/8586178752703844352
* Revision: Rev. 13, October 2016
.model OC_ONSEMI_MMBTA42LT1G NPN(IS=1.0000000000e-14 BF=9.5000000000e1 VAF=1.0000000000e2 IKF=1.0000000000e3 RB=1.0000000000e1 RC=1.0000000000e-1 RE=5.0000000000e-2 CJE=1.0000000000e-12 CJC=1.0000000000e-12 TF=1.0000000000e-9)

.temp 25
VCG1 cg1 0 DC 1.0000000000e1
IBG1 0 bg1 DC 4.0000000000e-5
QG1 cg1 bg1 0 OC_ONSEMI_MMBTA42LT1G
VCG2 cg2 0 DC 1.0000000000e1
IBG2 0 bg2 DC 2.5000000000e-4
QG2 cg2 bg2 0 OC_ONSEMI_MMBTA42LT1G
VCG3 cg3 0 DC 1.0000000000e1
IBG3 0 bg3 DC 7.5000000000e-4
QG3 cg3 bg3 0 OC_ONSEMI_MMBTA42LT1G
VCG4 cg4 0 DC 1.0000000000e1
IBG4 0 bg4 DC 1.0526315789e-6
QG4 cg4 bg4 0 OC_ONSEMI_MMBTA42LT1G
.op
.end
