OpenCircuit factory test: 2N5551 supported-region upper-current boundary
* OpenCircuit Model Factory v0.1.0
* Original work generated from public factual specifications.
* This model is not a copy of, or adaptation from, any vendor SPICE model.
* Source: https://www.onsemi.com/products/discrete-power-modules/bipolar-transistors/2N5551
* Revision: Manufacturer HTML specification page; accessed 2026-08-07
* Fit: native ngspice-46 in scipy.optimize.least_squares, diff_step=1e-4
.model OC_ONSEMI_2N5551 NPN(IS=1.7028053911e-14 NF=1.0000000000e0 BF=1.9999999996e3 IKF=7.0813223616e-4 ISE=1.6723817557e-18 NE=3.9999997440e0 VAF=1.0000000000e2 BR=4.0000000000e0 RB=1.0025165100e1 RE=9.2664885421e-1 RC=1.0323926427e-4 CJE=1.1836139835e-15 VJE=7.5000000000e-1 MJE=3.3000000000e-1 CJC=1.4445940663e-11 VJC=7.5000000000e-1 MJC=3.3000000000e-1 XCJC=1.0000000000e0 TF=1.5410432368e-9 TR=0 FC=0.5 EG=1.11 XTI=3 TNOM=27)

.temp 25
VC c 0 DC 5.0000000000e0
IB 0 b DC 1.6666666667e-3
Q1 c b 0 OC_ONSEMI_2N5551
.op
.end
