OpenCircuit factory test: 2N7002LT1G RDS(on)
* OpenCircuit Model Factory v0.1.0 bulk adapter
* Original work generated from public factual specifications.
* This model is not copied or adapted from any vendor SPICE model.
* Source: https://jlcpcb.com/api/file/downloadByFileSystemAccessId/8558248867360489472
* Revision: April 2013, Rev. 7; publication order number 2N7002L/D
.model OC_ONSEMI_2N7002LT1G VDMOS( VTO=2.5000000000e0 KP=2.6666666667e-1 THETA=0.0000000000e0 LAMBDA=3.0000000000e-3 RD=4.1250000000e0 RS=1.5000000000e0 RG=1.0000000000e-4 RDS=1e9 CGS=4.5000000000e-11 CGDMAX=5.0000000000e-12 CGDMIN=5.0000000000e-12 CJO=2.0000000000e-11 IS=1.0000000000e-12 N=1.5000000000e0 RB=1.5000000000e0)

.temp 25
M1 d1 g1 0 OC_ONSEMI_2N7002LT1G
ID1 0 d1 DC 5.0000000000e-1
VG1 g1 0 DC 1.0000000000e1
M2 d2 g2 0 OC_ONSEMI_2N7002LT1G
ID2 0 d2 DC 5.0000000000e-2
VG2 g2 0 DC 5.0000000000e0
.op
.end
