* OpenCircuit Model Factory v0.1.0 bulk adapter
* Original work generated from public factual specifications.
* This model is not copied or adapted from any vendor SPICE model.
* Source: https://jlcpcb.com/api/file/downloadByFileSystemAccessId/8586204810828136448
* Revision: April 2015 - Rev. 6, Publication Order Number 2N7002W/D
.model OC_ONSEMI_2N7002WT1G VDMOS( VTO=2.5000000000e0 KP=1.6806722689e0 THETA=0.0000000000e0 LAMBDA=3.0000000000e-3 RD=6.5450000000e-1 RS=2.3800000000e-1 RG=1.0000000000e-4 RDS=1e9 CGS=2.2300000000e-11 CGDMAX=2.2000000000e-12 CGDMIN=2.2000000000e-12 CJO=2.0000000000e-12 IS=1.0000000000e-12 N=1.5000000000e0 RB=2.3800000000e-1)
