OpenCircuit factory test: forward_03.cir
* OpenCircuit Model Factory v0.1.0
* Original work generated from public factual specifications.
* This model is not a copy of, or adaptation from, any vendor SPICE model.
* Source: https://www.onsemi.com/download/data-sheet/pdf/1n5820-d.pdf
* Revision: 1N5820/D Rev. 11, November 2023
* Fit: scipy.optimize.least_squares at 25 degC
.model OC_ONSEMI_1N5822 D(IS=4.1441411832e-6 N=1.0000000000e0 RS=5.9448239765e-2 CJO=7.0000000000e-10 TNOM=2.5000000000e1)

Itest 0 anode DC 9.4000000000e0
Vanchor anchor 0 DC 0
Ranchor anchor 0 1G
Ddut anode 0 OC_ONSEMI_1N5822
.op
.end
