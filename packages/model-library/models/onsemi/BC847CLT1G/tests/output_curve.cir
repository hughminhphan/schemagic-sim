OpenCircuit factory test: BC847CLT1G output sanity
* OpenCircuit Model Factory v0.1.0 bulk adapter
* Original work generated from public factual specifications.
* This model is not copied or adapted from any vendor SPICE model.
* Source: https://jlcpcb.com/api/file/downloadByFileSystemAccessId/8564047036254752768
* Revision: Rev. 17, January 2017
.model OC_ONSEMI_BC847CLT1G NPN(IS=1.0000000000e-14 BF=5.2000000000e2 VAF=1.0000000000e2 IKF=1.0000000000e3 RB=1.0000000000e1 RC=1.0000000000e-1 RE=5.0000000000e-2 CJE=1.0000000000e-12 CJC=1.0000000000e-12 TF=1.0000000000e-9)

.temp 25
VCE1 c1 0 DC 2
IB1 0 b1 DC 0.00001
Q1 c1 b1 0 OC_ONSEMI_BC847CLT1G
VCE2 c2 0 DC 10
IB2 0 b2 DC 0.00005
Q2 c2 b2 0 OC_ONSEMI_BC847CLT1G
.op
.end
