* OpenCircuit Model Factory v0.1.0
* Original work generated from public factual specifications.
* This model is not a copy of, or adaptation from, any vendor SPICE model.
* Source: https://www.onsemi.com/pdf/datasheet/tip41a-d.pdf
* Revision: TIP41A/D Rev. 12, June 2024
* Fit: native ngspice-46 in scipy.optimize.least_squares, diff_step=1e-4
.model OC_ONSEMI_TIP41C NPN(IS=8.8763105635e-12 NF=1.0000000000e0 BF=5.8998750765e2 IKF=4.5618663668e-1 ISE=2.8451751214e-11 NE=1.4084882985e0 VAF=6.0000000000e1 BR=2.0000000000e0 RB=1.2034702412e0 RE=1.4863771229e-2 RC=1.6279051820e-1 CJE=1.0000000000e-15 VJE=7.5000000000e-1 MJE=3.3000000000e-1 CJC=1.0000000000e-15 VJC=7.5000000000e-1 MJC=3.3000000000e-1 XCJC=1.0000000000e0 TF=1.0000000000e-12 TR=0 FC=0.5 EG=1.11 XTI=3 TNOM=27)
