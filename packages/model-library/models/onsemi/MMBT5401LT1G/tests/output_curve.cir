OpenCircuit factory test: MMBT5401LT1G output sanity
* OpenCircuit Model Factory v0.1.0 bulk adapter
* Original work generated from public factual specifications.
* This model is not copied or adapted from any vendor SPICE model.
* Source: https://jlcpcb.com/api/file/downloadByFileSystemAccessId/8586172884934922240
* Revision: Rev. 11, June 2012
.model OC_ONSEMI_MMBT5401LT1G PNP(IS=3.2034708367e-14 BF=1.2085471529e2 VAF=1.0000000000e2 IKF=1.1165281169e0 ISE=4.7856759950e-13 NE=1.5000000000e0 NF=1.0000000000e0 RB=1.0000000000e1 RC=1.0000000000e-1 RE=5.0000000000e-2 CJE=1.0000000000e-12 CJC=1.0000000000e-12 TF=1.0000000000e-9)

.temp 25
VCE1 c1 0 DC -2
IB1 0 b1 DC -0.00001
Q1 c1 b1 0 OC_ONSEMI_MMBT5401LT1G
VCE2 c2 0 DC -10
IB2 0 b2 DC -0.00005
Q2 c2 b2 0 OC_ONSEMI_MMBT5401LT1G
.op
.end
