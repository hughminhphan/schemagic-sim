OpenCircuit factory test: MMBT5401LT1G supported-region upper-current boundary
* OpenCircuit Model Factory v0.1.0 bulk adapter
* Original work generated from public factual specifications.
* This model is not copied or adapted from any vendor SPICE model.
* Source: https://jlcpcb.com/api/file/downloadByFileSystemAccessId/8586172884934922240
* Revision: Rev. 11, June 2012
.model OC_ONSEMI_MMBT5401LT1G PNP(IS=3.2034708367e-14 BF=1.2085471529e2 VAF=1.0000000000e2 IKF=1.1165281169e0 ISE=4.7856759950e-13 NE=1.5000000000e0 NF=1.0000000000e0 RB=1.0000000000e1 RC=1.0000000000e-1 RE=5.0000000000e-2 CJE=1.0000000000e-12 CJC=1.0000000000e-12 TF=1.0000000000e-9)

.temp 25
IC 0 c DC -1.0000000000e-1
IB 0 b DC -1.0000000000e-3
Q1 c b 0 OC_ONSEMI_MMBT5401LT1G
.op
.end
