* OpenCircuit Model Factory v0.1.0 bulk adapter
* Original work generated from public factual specifications.
* This model is not copied or adapted from any vendor SPICE model.
* Source: https://jlcpcb.com/api/file/downloadByFileSystemAccessId/8586172171408719872
* Revision: Rev. F1, June 2009
.model OC_ONSEMI_FDV301N VDMOS( VTO=8.5000000000e-1 KP=5.2631578947e-1 THETA=0.0000000000e0 LAMBDA=3.0000000000e-3 RD=2.0900000000e0 RS=7.6000000000e-1 RG=1.0000000000e-4 RDS=1e9 CGS=8.2000000000e-12 CGDMAX=1.3000000000e-12 CGDMIN=1.3000000000e-12 CJO=4.7000000000e-12 IS=1.0000000000e-12 N=1.5000000000e0 RB=7.6000000000e-1)
