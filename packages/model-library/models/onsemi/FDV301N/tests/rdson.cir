OpenCircuit factory test: FDV301N RDS(on)
* OpenCircuit Model Factory v0.1.0 bulk adapter
* Original work generated from public factual specifications.
* This model is not copied or adapted from any vendor SPICE model.
* Source: https://jlcpcb.com/api/file/downloadByFileSystemAccessId/8586172171408719872
* Revision: Rev. F1, June 2009
.model OC_ONSEMI_FDV301N VDMOS( VTO=8.5000000000e-1 KP=5.2631578947e-1 THETA=0.0000000000e0 LAMBDA=3.0000000000e-3 RD=2.0900000000e0 RS=7.6000000000e-1 RG=1.0000000000e-4 RDS=1e9 CGS=8.2000000000e-12 CGDMAX=1.3000000000e-12 CGDMIN=1.3000000000e-12 CJO=4.7000000000e-12 IS=1.0000000000e-12 N=1.5000000000e0 RB=7.6000000000e-1)

.temp 25
M1 d1 g1 0 OC_ONSEMI_FDV301N
ID1 0 d1 DC 2.0000000000e-1
VG1 g1 0 DC 2.7000000000e0
M2 d2 g2 0 OC_ONSEMI_FDV301N
ID2 0 d2 DC 2.0000000000e-1
VG2 g2 0 DC 2.7000000000e0
M3 d3 g3 0 OC_ONSEMI_FDV301N
ID3 0 d3 DC 4.0000000000e-1
VG3 g3 0 DC 4.5000000000e0
M4 d4 g4 0 OC_ONSEMI_FDV301N
ID4 0 d4 DC 4.0000000000e-1
VG4 g4 0 DC 4.5000000000e0
.op
.end
