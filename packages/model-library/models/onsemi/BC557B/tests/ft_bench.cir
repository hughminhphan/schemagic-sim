OpenCircuit factory test: BC557B fT
* OpenCircuit Model Factory v0.1.0
* Original work generated from public factual specifications.
* This model is not a copy of, or adaptation from, any vendor SPICE model.
* Source: https://www.onsemi.com/pub/Collateral/BC556B-D.PDF
* Revision: Rev. 3, March 2007
* Fit: native ngspice-46 in scipy.optimize.least_squares, diff_step=1e-4
.model OC_ONSEMI_BC557B PNP(IS=4.3206219081e-14 NF=1.0000000000e+00 BF=4.9999997365e+03 IKF=1.1068813359e-02 ISE=1.2082169788e-13 NE=1.3679363086e+00 VAF=1.0000000000e+02 BR=4.0000000000e+00 RB=3.1377399015e+00 RE=1.0000000000e-04 RC=9.2197527351e-01 CJE=1.1836139835e-11 VJE=7.5000000000e-01 MJE=3.3000000000e-01 CJC=7.2229703317e-12 VJC=7.5000000000e-01 MJC=3.3000000000e-01 XCJC=1.0000000000e+00 TF=4.3869175971e-10 TR=0.0000000000e+00 FC=5.0000000000e-01 EG=1.1100000000e+00 XTI=3.0000000000e+00 TNOM=2.7000000000e+01)

.temp 25
VCC c 0 DC -5.0000000000e0
IBDC 0 b DC -6.6666666667e-5
IAC 0 b AC 1
Q1 c b 0 OC_ONSEMI_BC557B
.ac dec 20 1Meg 10G
.end
