OpenCircuit factory test: forward_01.cir
* OpenCircuit Model Factory v0.1.0
* Original work generated from public factual specifications.
* This model is not a copy of, or adaptation from, any vendor SPICE model.
* Source: https://components101.com/sites/default/files/component_datasheet/SS14%20Schottky%20Diode.PDF
* Revision: SS12/D Rev. 3, July 2005; archived onsemi PDF mirror
* Fit: scipy.optimize.least_squares at 25 degC
.model OC_ONSEMI_SS14 D(IS=1.7322099581e-7 N=1.1000000000e0 RS=3.0000000000e-2 CJO=1.8000000000e-10 TNOM=2.5000000000e1)

Itest 0 anode DC 1.0000000000e0
Vanchor anchor 0 DC 0
Ranchor anchor 0 1G
Ddut anode 0 OC_ONSEMI_SS14
.op
.end
