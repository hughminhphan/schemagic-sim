MMBF5457 typical transfer points
* OpenCircuit Model Factory JFET manual path v0.1.0
* Original work generated from public factual specifications.
* This model is not a copy of, or adaptation from, any vendor SPICE model.
* Source: https://www.onsemi.cn/pdf/datasheet/mmbf5457-d.pdf
* Revision: Rev. 1, January 2023
* Fit: native ngspice-46 in scipy.optimize.least_squares, diff_step=1e-4
* Node order: J<ref> drain gate source OC_MMBF5457
.model OC_MMBF5457 NJF (
+ VTO=-1.7975011557e+00 BETA=8.9792154740e-04 LAMBDA=3.5081965425e-03 B=9.5109085031e-01
+ RD=1.0000000000e-04 RS=1.0000000000e-04
+ CGS=3.0000000000e-12 CGD=6.0000000000e-12 PB=1.0 M=0.5 FC=0.5
+ IS=1.0000000000e-20 N=1.0 TNOM=27
+)
.temp 25
J0 d0 0 0 OC_MMBF5457
VD0 d0 0 DC 15
J1 d1 g1 0 OC_MMBF5457
VD1 d1 0 DC 15
VG1 g1 0 DC -0.5
J2 d2 g2 0 OC_MMBF5457
VD2 d2 0 DC 15
VG2 g2 0 DC -1.0
J3 d3 g3 0 OC_MMBF5457
VD3 d3 0 DC 15
VG3 g3 0 DC -1.5
.op
.end
