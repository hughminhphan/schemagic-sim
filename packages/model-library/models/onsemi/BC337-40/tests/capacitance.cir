OpenCircuit factory test: BC337-40 Cobo
* OpenCircuit Model Factory v0.1.0
* Original work generated from public factual specifications.
* This model is not a copy of, or adaptation from, any vendor SPICE model.
* Source: https://www.onsemi.com/products/discrete-semiconductors/bipolar-transistors/bc337
* Revision: Manufacturer product specification page, accessed 2026-08-07
* Fit: native ngspice-46 in scipy.optimize.least_squares, diff_step=1e-4
.model OC_ONSEMI_BC337_40 NPN(IS=8.0000000000e-14 NF=1.0000000000e+00 BF=5.2000000000e+02 IKF=2.8000000000e-01 ISE=4.0000000000e-10 NE=4.0000000000e+00 VAF=1.0000000000e+02 BR=4.0000000000e+00 RB=1.2000000000e+01 RE=1.0000000000e-01 RC=3.0000000000e-01 CJE=1.4203367802e-11 VJE=7.5000000000e-01 MJE=3.3000000000e-01 CJC=2.8891881327e-11 VJC=7.5000000000e-01 MJC=3.3000000000e-01 XCJC=1.0000000000e+00 TF=1.4673775916e-09 TR=0.0000000000e+00 FC=5.0000000000e-01 EG=1.1100000000e+00 XTI=3.0000000000e+00 TNOM=2.7000000000e+01)

.temp 25
VCB c 0 DC 10 AC 1
Q1 c b 0 OC_ONSEMI_BC337_40
VB b 0 DC 0
.ac lin 1 1Meg 1Meg
.end
