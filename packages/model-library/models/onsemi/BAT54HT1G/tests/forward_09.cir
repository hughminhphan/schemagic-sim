OpenCircuit factory test: forward_09.cir
* OpenCircuit Model Factory v0.1.0 bulk adapter
* Original work generated from public factual specifications.
* This model is not copied or adapted from any vendor SPICE model.
* Source: https://jlcpcb.com/api/file/downloadByFileSystemAccessId/8586172785060155392
* Revision: October 2005 - Rev. 3
.model OC_ONSEMI_BAT54HT1G D(IS=2.5699918955e-8 N=1.0424327453e0 RS=1.1332015140e0)

.temp 25
Itest 0 anode DC 3.0000000000e-2
Vanchor anchor 0 DC 0
Ranchor anchor 0 1G
Ddut anode 0 OC_ONSEMI_BAT54HT1G
.op
.end
