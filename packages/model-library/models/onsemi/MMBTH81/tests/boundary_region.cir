OpenCircuit factory test: MMBTH81 supported-region upper-current boundary
* OpenCircuit Model Factory v0.1.0 bulk adapter
* Original work generated from public factual specifications.
* This model is not copied or adapted from any vendor SPICE model.
* Source: https://jlcpcb.com/api/file/downloadByFileSystemAccessId/8586188983088910336
* Revision: Reverse Current
.model OC_ONSEMI_MMBTH81 PNP(IS=1.0000000000e-14 BF=6.0000000000e1 VAF=1.0000000000e2 IKF=1.0000000000e3 RB=1.0000000000e1 RC=1.0000000000e-1 RE=5.0000000000e-2 CJE=1.0000000000e-12 CJC=1.0000000000e-12 TF=1.0000000000e-9)

.temp 25
IC 0 c DC -5.0000000000e-3
IB 0 b DC -8.3333333333e-5
Q1 c b 0 OC_ONSEMI_MMBTH81
.op
.end
