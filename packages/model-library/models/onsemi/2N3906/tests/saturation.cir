OpenCircuit factory test: 2N3906 saturation
* OpenCircuit Model Factory v0.1.0
* Original work generated from public factual specifications.
* This model is not a copy of, or adaptation from, any vendor SPICE model.
* Source: https://www.onsemi.com/pub/Collateral/2N3906-D.PDF
* Revision: Rev. 4, February 2010
* Fit: native ngspice-46 in scipy.optimize.least_squares, diff_step=1e-4
.model OC_ONSEMI_2N3906 PNP(IS=1.4619035428e-14 NF=1.0000000000e+00 BF=2.2245660895e+02 IKF=9.1775814571e-02 ISE=1.2057663775e-11 NE=2.1709114979e+00 VAF=1.0000000000e+02 BR=4.0000000000e+00 RB=1.8406353065e+01 RE=1.0000000000e-04 RC=3.4867336277e+00 CJE=1.1836139835e-11 VJE=7.5000000000e-01 MJE=3.3000000000e-01 CJC=8.8131809209e-12 VJC=7.5000000000e-01 MJC=3.3000000000e-01 XCJC=1.0000000000e+00 TF=5.5283624603e-10 TR=0.0000000000e+00 FC=5.0000000000e-01 EG=1.1100000000e+00 XTI=3.0000000000e+00 TNOM=2.7000000000e+01)

.temp 25
ICS1 0 cs1 DC -1.0000000000e-2
IBS1 0 bs1 DC -1.0000000000e-3
QS1 cs1 bs1 0 OC_ONSEMI_2N3906
ICS2 0 cs2 DC -5.0000000000e-2
IBS2 0 bs2 DC -5.0000000000e-3
QS2 cs2 bs2 0 OC_ONSEMI_2N3906
.op
.end
