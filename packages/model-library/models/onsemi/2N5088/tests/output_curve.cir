OpenCircuit factory test: 2N5088 output sanity
* OpenCircuit Model Factory v0.1.0
* Original work generated from public factual specifications.
* This model is not a copy of, or adaptation from, any vendor SPICE model.
* Source: https://www.onsemi.com/pdf/datasheet/2n5088-d.pdf
* Revision: 2N5088/2N5089/MMBT5088/MMBT5089 Rev. A, 2001
* Fit: native ngspice-46 in scipy.optimize.least_squares, diff_step=1e-4
.model OC_ONSEMI_2N5088 NPN(IS=6.9240708870e-12 NF=1.0000000000e0 BF=5.0361902135e2 IKF=3.8883350799e-2 ISE=1.1968833206e-13 NE=1.6085478532e0 VAF=1.0000000000e2 BR=4.0000000000e0 RB=1.0007225080e1 RE=5.8168842776e0 RC=2.9527531449e1 CJE=1.1836139835e-11 VJE=7.5000000000e-1 MJE=3.3000000000e-1 CJC=7.8339385963e-12 VJC=7.5000000000e-1 MJC=3.3000000000e-1 XCJC=1.0000000000e0 TF=1.8954627865e-9 TR=0 FC=0.5 EG=1.11 XTI=3 TNOM=27)

.temp 25
VCE1 c1 0 DC 2
IB1 0 b1 DC 0.00001
Q1 c1 b1 0 OC_ONSEMI_2N5088
VCE2 c2 0 DC 10
IB2 0 b2 DC 0.00005
Q2 c2 b2 0 OC_ONSEMI_2N5088
.op
.end
