* OpenCircuit Model Factory v0.1.0 bulk adapter
* Original work generated from public factual specifications.
* This model is not copied or adapted from any vendor SPICE model.
* Source: https://jlcpcb.com/api/file/downloadByFileSystemAccessId/8588911466607226880
* Revision: October 2017, Rev. 3
.model OC_ONSEMI_FDN5618P VDMOS( pchan VTO=-1.6000000000e0 KP=1.1764705882e1 THETA=0.0000000000e0 LAMBDA=3.0000000000e-3 RD=9.3500000000e-2 RS=3.4000000000e-2 RG=1.0000000000e-4 RDS=1e9 CGS=4.1100000000e-10 CGDMAX=1.9000000000e-11 CGDMIN=1.9000000000e-11 CJO=3.3000000000e-11 IS=1.0000000000e-12 N=1.5000000000e0 RB=3.4000000000e-2)
