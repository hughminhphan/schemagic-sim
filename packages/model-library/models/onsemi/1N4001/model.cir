* OpenCircuit Model Factory v0.1.0
* Original work generated from public factual specifications.
* 1N4001 (onsemi), official product specification fallback, fitted 2026-08-07
* Archetype: archetype-diode.md, variant S
* Node order: D<ref> anode cathode OC_ONSEMI_1N4001
* Official datasheet PDF and product page were unreachable; F1 fallback uses one-sided published MAX bounds.
.model OC_ONSEMI_1N4001 D(IS=1.0000000000e-10 N=1.6000000000e00 RS=1.2000000000e-01)
