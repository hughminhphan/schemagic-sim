* OpenCircuit Model Factory v0.1.0 bulk adapter
* Original work generated from public factual specifications.
* This model is not copied or adapted from any vendor SPICE model.
* Source: https://jlcpcb.com/api/file/downloadByFileSystemAccessId/8586203218678591488
* Revision: Rev. 3 (December 2014)
.model OC_ONSEMI_NTZD3154NT1G VDMOS( VTO=1.0000000000e0 KP=5.0000000000e0 THETA=0.0000000000e0 LAMBDA=3.0000000000e-3 RD=2.2000000000e-1 RS=8.0000000000e-2 RG=1.0000000000e-4 RDS=1e9 CGS=7.0000000000e-11 CGDMAX=1.0000000000e-11 CGDMIN=1.0000000000e-11 CJO=3.0000000000e-12 IS=1.0000000000e-12 N=1.5000000000e0 RB=8.0000000000e-2)
