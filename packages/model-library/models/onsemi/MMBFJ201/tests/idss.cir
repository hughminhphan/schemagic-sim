MMBFJ201 IDSS and transconductance
* OpenCircuit Model Factory JFET manual path v0.1.0
* Original work generated from public factual specifications.
* This model is not a copy of, or adaptation from, any vendor SPICE model.
* Source: https://www.onsemi.cn/pdf/datasheet/mmbfj202-d.pdf
* Revision: Rev. 5, April 2026
* Fit: native ngspice-46 in scipy.optimize.least_squares, diff_step=1e-4
* Node order: J<ref> drain gate source OC_MMBFJ201
.model OC_MMBFJ201 NJF (
+ VTO=-7.9111001584e-01 BETA=4.3469553867e-04 LAMBDA=1.8419894651e-02 B=1.4999999835e+00
+ RD=1.0000000000e-04 RS=1.0000000000e-04
+ CGS=4.2500000000e-12 CGD=2.5204166322e-12 PB=1.0 M=0.5 FC=0.5
+ IS=1.0000000000e-20 N=1.0 TNOM=27
+)
.temp 25
J1 d 0 0 OC_MMBFJ201
VD d 0 DC 20
.save i(VD) @j1[id] @j1[gm]
.op
.end
