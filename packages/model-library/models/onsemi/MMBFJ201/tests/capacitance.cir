MMBFJ201 capacitance from typical curves
* OpenCircuit Model Factory JFET manual path v0.1.0
* Original work generated from public factual specifications.
* This model is not a copy of, or adaptation from, any vendor SPICE model.
* Source: https://www.onsemi.cn/pdf/datasheet/mmbfj202-d.pdf
* Revision: Rev. 5, April 2026
* Fit: native ngspice-46 in scipy.optimize.least_squares, diff_step=1e-4
* Node order: J<ref> drain gate source OC_MMBFJ201
.model OC_MMBFJ201 NJF (
+ VTO=-8.0677333042e-01 BETA=5.4119659846e-04 LAMBDA=1.8497834150e-02 B=1.0000000000e+00
+ RD=1.0000000000e-04 RS=1.0000000000e-04
+ CGS=4.2500000000e-12 CGD=2.5204166322e-12 PB=1.0 M=0.5 FC=0.5
+ IS=1.0000000000e-20 N=1.0 TNOM=27
+)
.temp 25
JIN din gin 0 OC_MMBFJ201
VDIN din 0 DC 20
VGIN gin 0 DC 0 AC 1
JOUT dout 0 0 OC_MMBFJ201
VDOUT dout 0 DC 20 AC 1
.ac lin 1 1Meg 1Meg
.end
