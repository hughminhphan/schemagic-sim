OpenCircuit factory test: BSS123LT1G RDS(on)
* OpenCircuit Model Factory v0.1.0 bulk adapter
* Original work generated from public factual specifications.
* This model is not copied or adapted from any vendor SPICE model.
* Source: https://jlcpcb.com/api/file/downloadByFileSystemAccessId/8586176189903327232
* Revision: Rev. 9
.model OC_ONSEMI_BSS123LT1G VDMOS( VTO=2.6000000000e0 KP=3.3333333333e-1 THETA=0.0000000000e0 LAMBDA=3.0000000000e-3 RD=3.3000000000e0 RS=1.2000000000e0 RG=1.0000000000e-4 RDS=1e9 CGS=1.6000000000e-11 CGDMAX=4.0000000000e-12 CGDMIN=4.0000000000e-12 CJO=5.0000000000e-12 IS=1.0000000000e-12 N=1.5000000000e0 RB=1.2000000000e0)

.temp 25
M1 d1 g1 0 OC_ONSEMI_BSS123LT1G
ID1 0 d1 DC 1.0000000000e-1
VG1 g1 0 DC 1.0000000000e1
.op
.end
