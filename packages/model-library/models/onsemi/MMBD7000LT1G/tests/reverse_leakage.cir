OpenCircuit factory test: reverse leakage
* OpenCircuit Model Factory v0.1.0 bulk adapter
* Original work generated from public factual specifications.
* This model is not copied or adapted from any vendor SPICE model.
* Source: https://jlcpcb.com/api/file/downloadByFileSystemAccessId/8586175462753619968
* Revision: June 2017 - Rev. 8
.model OC_ONSEMI_MMBD7000LT1G D(IS=3.1364881321e-9 N=1.8724910058e0 RS=1.0307911199e0)

.temp 25
Vreverse cathode 0 DC 5.0000000000e1
Ddut 0 cathode OC_ONSEMI_MMBD7000LT1G
.op
.end
