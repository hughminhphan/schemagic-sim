OpenCircuit factory test: NTMFS5C430NLT1G RDS(on)
* OpenCircuit Model Factory v0.1.0 bulk adapter
* Original work generated from public factual specifications.
* This model is not copied or adapted from any vendor SPICE model.
* Source: https://jlcpcb.com/api/file/downloadByFileSystemAccessId/8588886809937907712
* Revision: May 2019 - Rev. 3, Publication Order Number NTMFS5C430NL/D
.model OC_ONSEMI_NTMFS5C430NLT1G VDMOS( VTO=2.0000000000e0 KP=1.6666666667e3 THETA=0.0000000000e0 LAMBDA=3.0000000000e-3 RD=6.6000000000e-4 RS=2.4000000000e-4 RG=1.0000000000e-4 RDS=1e9 CGS=4.2280000000e-9 CGDMAX=7.2000000000e-11 CGDMIN=7.2000000000e-11 CJO=1.8280000000e-9 IS=1.0000000000e-12 N=1.5000000000e0 RB=2.4000000000e-4)

.temp 25
M1 d1 g1 0 OC_ONSEMI_NTMFS5C430NLT1G
ID1 0 d1 DC 5.0000000000e1
VG1 g1 0 DC 1.0000000000e1
.op
.end
