OpenCircuit factory test: forward_04.cir
* OpenCircuit Model Factory v0.1.0
* Original work generated from public factual specifications.
* This model is not a copy of, or adaptation from, any vendor SPICE model.
* Source: https://www.onsemi.com/pdf/datasheet/bzx84c2v4lt1-d.pdf
* Revision: BZX84C2V4LT1/D Rev. 23, August 2021
* Fit: scipy.optimize.least_squares at 25 degC
.model OC_ONSEMI_BZX84C5V1 D(IS=3.5043902426e-13 N=1.2137906779e0 RS=1.5528888588e-1 CJO=2.2500000000e-10 BV=5.1000000000e0 IBV=5.0000000000e-3 NBV=1.0000000000e0 TNOM=2.5000000000e1)

Itest 0 anode DC 5.0000000000e-1
Vanchor anchor 0 DC 0
Ranchor anchor 0 1G
Ddut anode 0 OC_ONSEMI_BZX84C5V1
.op
.end
