OpenCircuit factory test: NTJD4001NT1G RDS(on)
* OpenCircuit Model Factory v0.1.0 bulk adapter
* Original work generated from public factual specifications.
* This model is not copied or adapted from any vendor SPICE model.
* Source: https://jlcpcb.com/api/file/downloadByFileSystemAccessId/8586204812145012736
* Revision: Publication Order Number NTJD4001N/D, May 2019 Rev. 7
.model OC_ONSEMI_NTJD4001NT1G VDMOS( VTO=1.2000000000e0 KP=2.0000000000e0 THETA=0.0000000000e0 LAMBDA=3.0000000000e-3 RD=5.5000000000e-1 RS=2.0000000000e-1 RG=1.0000000000e-4 RDS=1e9 CGS=1.2750000000e-11 CGDMAX=7.2500000000e-12 CGDMIN=7.2500000000e-12 CJO=1.1750000000e-11 IS=1.0000000000e-12 N=1.5000000000e0 RB=2.0000000000e-1)

.temp 25
M1 d1 g1 0 OC_ONSEMI_NTJD4001NT1G
ID1 0 d1 DC 1.0000000000e-2
VG1 g1 0 DC 4.0000000000e0
.op
.end
