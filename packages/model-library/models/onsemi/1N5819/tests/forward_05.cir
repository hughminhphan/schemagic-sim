OpenCircuit factory test: 1N5819 forward at 1 A
* OpenCircuit Model Factory v0.1.0
* Original work generated from public factual specifications.
* This model is not a copy of, or adaptation from, any vendor SPICE model.
* Source: https://www.onsemi.com/download/data-sheet/pdf/1n5817-d.pdf
* Revision: August 2021, Rev. 11
* Fit: native ngspice-46 in scipy.optimize.least_squares at 25 degC, diff_step=1e-4
* Archetype: archetype-diode.md, variant K
.model OC_ONSEMI_1N5819 D(IS=1.007620043239e-05 N=1.35521820797 RS=0.0378890034316 ISR=1.799000000000e-04 NR=2 CJO=1.598435887845e-10 VJ=1.2 M=0.540102308336 FC=0.5 TT=0 TNOM=25)
.temp 25
Itest 0 anode DC 1.000000000000e+00
Vanchor anchor 0 DC 0
Ranchor anchor 0 1G
Ddut anode 0 OC_ONSEMI_1N5819
.op
.end
