OpenCircuit factory test: 1N5819 junction capacitance
* OpenCircuit Model Factory v0.1.0
* Original work generated from public factual specifications.
* This model is not a copy of, or adaptation from, any vendor SPICE model.
* Source: https://www.onsemi.com/download/data-sheet/pdf/1n5817-d.pdf
* Revision: August 2021, Rev. 11
* Fit: native ngspice-46 in scipy.optimize.least_squares at 25 degC, diff_step=1e-4
* Archetype: archetype-diode.md, variant K
.model OC_ONSEMI_1N5819 D(IS=1.007620043239e-05 N=1.35521820797 RS=0.0378890034316 ISR=1.799000000000e-04 NR=2 CJO=1.598435887845e-10 VJ=1.2 M=0.540102308336 FC=0.5 TT=0 TNOM=25)
.temp 25
V1 cathode1 0 DC 0.5 AC 1
D1 0 cathode1 OC_ONSEMI_1N5819
V2 cathode2 0 DC 1 AC 1
D2 0 cathode2 OC_ONSEMI_1N5819
V3 cathode3 0 DC 2 AC 1
D3 0 cathode3 OC_ONSEMI_1N5819
V4 cathode4 0 DC 4 AC 1
D4 0 cathode4 OC_ONSEMI_1N5819
V5 cathode5 0 DC 8 AC 1
D5 0 cathode5 OC_ONSEMI_1N5819
V6 cathode6 0 DC 16 AC 1
D6 0 cathode6 OC_ONSEMI_1N5819
V7 cathode7 0 DC 32 AC 1
D7 0 cathode7 OC_ONSEMI_1N5819
.ac lin 1 1Meg 1Meg
.end
