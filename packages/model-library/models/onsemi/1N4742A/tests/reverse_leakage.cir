* 1N4742A reverse leakage at datasheet test voltage
* OpenCircuit Model Factory v0.1.0
* Original work generated from public factual specifications.
* This model is not a copy of, or adaptation from, any vendor SPICE model.
* Source: https://www.onsemi.com/products/discrete-power-modules/zener-diodes/1N4742A
* Revision: official product specification fallback; PDF and product page access blocked
* Archetype: archetype-diode.md, variant Z; fit reference 25 degC
* Node order: D1 anode cathode OC_ONSEMI_1N4742A
.model OC_ONSEMI_1N4742A D(IS=1e-14 N=1.6 RS=1.0000000000e-04 BV=1.2000000000e+01 IBV=2.1000000000e-02 NBV=1.0000000000e+00)
.temp 25
Vreverse cathode 0 DC 9.1
Vanchor anchor 0 DC 0
Ranchor anchor 0 1G
D1 0 cathode OC_ONSEMI_1N4742A
.op
.end
