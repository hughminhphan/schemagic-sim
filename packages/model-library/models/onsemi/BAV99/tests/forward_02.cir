* BAV99 forward boundary at 0.015 A
* OpenCircuit Model Factory v0.1.0
* Original work generated from public factual specifications.
* BAV99 (onsemi), official product specification fallback, fitted 2026-08-07
* Archetype: archetype-diode.md, variant S
* Node order: D<ref> anode cathode OC_ONSEMI_BAV99
* Official datasheet PDF and product page were unreachable; F1 fallback uses one-sided published MAX bounds.
.model OC_ONSEMI_BAV99 D(IS=1.0000000000e-12 N=1.8000000000e00 RS=2.0000000000e-01)
.temp 25
Itest 0 anode DC 1.5000000000e-02
Vanchor anchor 0 DC 0
Ranchor anchor 0 1G
Ddut anode 0 OC_ONSEMI_BAV99
.op
.end
