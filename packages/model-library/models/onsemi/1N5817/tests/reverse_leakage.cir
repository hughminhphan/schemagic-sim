* 1N5817 reverse leakage at datasheet condition
* OpenCircuit Model Factory v0.1.0
* Original work generated from public factual specifications.
* 1N5817 (onsemi), official product specification fallback, fitted 2026-08-07
* Archetype: archetype-diode.md, variant K
* Node order: D<ref> anode cathode OC_ONSEMI_1N5817
* Official datasheet PDF and product page were unreachable; F1 fallback uses one-sided published MAX bounds.
.model OC_ONSEMI_1N5817 D(IS=2.0000000000e-06 N=1.1000000000e00 RS=6.0000000000e-02)
.temp 25
Vreverse cathode 0 DC 2.0000000000e01
Ddut 0 cathode OC_ONSEMI_1N5817
.op
.end
