* OpenCircuit Model Factory v0.1.0 bulk adapter
* Original work generated from public factual specifications.
* This model is not copied or adapted from any vendor SPICE model.
* Source: https://jlcpcb.com/api/file/downloadByFileSystemAccessId/8586177058720387072
* Revision: October 2016, Rev. 12
.model OC_ONSEMI_BAV70LT1G D(IS=7.2061172376e-10 N=1.6696378784e0 RS=9.2625071877e-1)
