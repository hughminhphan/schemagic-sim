OpenCircuit factory test: TIP42C DC gain
* OpenCircuit Model Factory v0.1.0
* Original work generated from public factual specifications.
* This model is not a copy of, or adaptation from, any vendor SPICE model.
* Source: https://www.onsemi.com/pdf/datasheet/tip41a-d.pdf
* Revision: TIP41A/D Rev. 12, June 2024
* Fit: native ngspice-46 in scipy.optimize.least_squares, diff_step=1e-4
.model OC_ONSEMI_TIP42C PNP(IS=8.8764021753e-12 NF=1.0000000000e0 BF=5.8997052909e2 IKF=4.5618739147e-1 ISE=2.8452940725e-11 NE=1.4084915143e0 VAF=6.0000000000e1 BR=2.0000000000e0 RB=1.2034707728e0 RE=1.4863773718e-2 RC=1.6279048734e-1 CJE=1.0000000000e-15 VJE=7.5000000000e-1 MJE=3.3000000000e-1 CJC=1.0000000000e-15 VJC=7.5000000000e-1 MJC=3.3000000000e-1 XCJC=1.0000000000e0 TF=1.0000000000e-12 TR=0 FC=0.5 EG=1.11 XTI=3 TNOM=27)

.temp 25
VCG1 cg1 0 DC -4.0000000000e0
IBG1 0 bg1 DC -1.0000000000e-2
QG1 cg1 bg1 0 OC_ONSEMI_TIP42C
VCG2 cg2 0 DC -4.0000000000e0
IBG2 0 bg2 DC -2.0000000000e-1
QG2 cg2 bg2 0 OC_ONSEMI_TIP42C
.op
.end
