* OpenCircuit Model Factory v0.1.0
* Original work generated from public factual specifications.
* 1N4007 (onsemi), onsemi family datasheet, fitted 2026-08-07
* Archetype: archetype-diode.md, variant S
* Node order: D<ref> anode cathode OC_ONSEMI_1N4007
* F1 one-sided-bound model uses published maximum specifications; no typical forward-IV curve was fitted.
.model OC_ONSEMI_1N4007 D(IS=1.0000000000e-10 N=1.6000000000e00 RS=1.2000000000e-01)
