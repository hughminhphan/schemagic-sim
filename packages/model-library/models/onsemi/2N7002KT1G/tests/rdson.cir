OpenCircuit factory test: 2N7002KT1G RDS(on)
* OpenCircuit Model Factory v0.1.0 bulk adapter
* Original work generated from public factual specifications.
* This model is not copied or adapted from any vendor SPICE model.
* Source: https://jlcpcb.com/api/file/downloadByFileSystemAccessId/8588880663197978624
* Revision: October 2016, Rev. 15
.model OC_ONSEMI_2N7002KT1G VDMOS( VTO=2.3000000000e0 KP=1.6806722689e0 THETA=0.0000000000e0 LAMBDA=3.0000000000e-3 RD=6.5450000000e-1 RS=2.3800000000e-1 RG=1.0000000000e-4 RDS=1e9 CGS=2.2300000000e-11 CGDMAX=2.2000000000e-12 CGDMIN=2.2000000000e-12 CJO=2.0000000000e-12 IS=1.0000000000e-12 N=1.5000000000e0 RB=2.3800000000e-1)

.temp 25
M1 d1 g1 0 OC_ONSEMI_2N7002KT1G
ID1 0 d1 DC 5.0000000000e-1
VG1 g1 0 DC 1.0000000000e1
M2 d2 g2 0 OC_ONSEMI_2N7002KT1G
ID2 0 d2 DC 2.0000000000e-1
VG2 g2 0 DC 4.5000000000e0
.op
.end
