* 1N5408 reverse leakage at datasheet condition
* OpenCircuit Model Factory v0.1.0
* Original work generated from public factual specifications.
* 1N5408 (onsemi), official product specification fallback, fitted 2026-08-07
* Archetype: archetype-diode.md, variant S
* Node order: D<ref> anode cathode OC_ONSEMI_1N5408
* Official datasheet PDF and product page were unreachable; F1 fallback uses one-sided published MAX bounds.
.model OC_ONSEMI_1N5408 D(IS=1.0000000000e-09 N=1.6000000000e00 RS=8.0000000000e-02)
.temp 25
Vreverse cathode 0 DC 1.0000000000e03
Ddut 0 cathode OC_ONSEMI_1N5408
.op
.end
