* 1N5408 supported-region boundary at rated continuous current
* OpenCircuit Model Factory v0.1.0
* Original work generated from public factual specifications.
* 1N5408 (onsemi), onsemi family datasheet, fitted 2026-08-07
* Archetype: archetype-diode.md, variant S
* Node order: D<ref> anode cathode OC_ONSEMI_1N5408
* F1 one-sided-bound model uses published maximum specifications; no typical forward-IV curve was fitted.
.model OC_ONSEMI_1N5408 D(IS=1.0000000000e-09 N=1.6000000000e00 RS=3.0000000000e-02)
.temp 25
Itest 0 anode DC 3.0000000000e00
Vanchor anchor 0 DC 0
Ranchor anchor 0 1G
Ddut anode 0 OC_ONSEMI_1N5408
.op
.end
