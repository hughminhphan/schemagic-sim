OpenCircuit factory test: forward_05.cir
* OpenCircuit Model Factory v0.1.0 bulk adapter
* Original work generated from public factual specifications.
* This model is not copied or adapted from any vendor SPICE model.
* Source: https://jlcpcb.com/api/file/downloadByFileSystemAccessId/8586171992684285952
* Revision: November 2011, Rev. 15
.model OC_ONSEMI_BAT54SLT1G D(IS=1.7649087701e-8 N=9.9366247430e-1 RS=5.9140945165e-1)

.temp 25
Itest 0 anode DC 1.0000000000e-4
Vanchor anchor 0 DC 0
Ranchor anchor 0 1G
Ddut anode 0 OC_ONSEMI_BAT54SLT1G
.op
.end
