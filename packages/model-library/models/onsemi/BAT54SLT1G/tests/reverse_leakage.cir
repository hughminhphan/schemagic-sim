OpenCircuit factory test: reverse leakage
* OpenCircuit Model Factory v0.1.0 bulk adapter
* Original work generated from public factual specifications.
* This model is not copied or adapted from any vendor SPICE model.
* Source: https://jlcpcb.com/api/file/downloadByFileSystemAccessId/8586171992684285952
* Revision: November 2011, Rev. 15
.model OC_ONSEMI_BAT54SLT1G D(IS=1.7649087701e-8 N=9.9366247430e-1 RS=5.9140945165e-1)

.temp 25
Vreverse cathode 0 DC 2.5000000000e1
Ddut 0 cathode OC_ONSEMI_BAT54SLT1G
.op
.end
