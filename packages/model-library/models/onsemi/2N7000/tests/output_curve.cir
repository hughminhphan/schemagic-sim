2N7000 typical output-curve points at 25 degC
.temp 25
* OpenCircuit Model Factory v0.1.0
* Original work generated from public factual specifications.
* This model is not a copy of, or adaptation from, any vendor SPICE model.
* Source: https://www.onsemi.cn/download/data-sheet/pdf/2n7000-d.pdf
* Revision: Rev. 8, April 2011
* Fit: native ngspice-46 typical-curve family at 25 degC; three-seed sweep
* Node order: drain gate source
.model OC_2N7000 VDMOS(VTO=2.0228743922e+00 KP=9.2617165307e-02 THETA=2.9259180179e-02 LAMBDA=3.0000000000e-03 RD=4.1251998829e-01 RS=5.0000000000e-01 RG=1.0000000000e-04 RDS=1e9 CGS=5.5000000000e-11 CGDMAX=5.0000000000e-12 CGDMIN=5.0000000000e-12 A=1.0000000000e+00 CJO=1.1337000000e-10 VJ=0.8 M=0.5 FC=0.5 IS=1.0000000000e-14 N=1.5000000000e+00 RB=5.0000000000e-01 TT=0 BV=6.0000000000e+01 IBV=1.0000000000e-05 NBV=1 RTHJC=0 RTHCA=3.5700000000e+02 TNOM=27)
M1 d1 g1 0 OC_2N7000
VD1 d1 0 DC 1
VG1 g1 0 DC 4
M2 d2 g2 0 OC_2N7000
VD2 d2 0 DC 5
VG2 g2 0 DC 4
M3 d3 g3 0 OC_2N7000
VD3 d3 0 DC 1
VG3 g3 0 DC 5
M4 d4 g4 0 OC_2N7000
VD4 d4 0 DC 5
VG4 g4 0 DC 5
M5 d5 g5 0 OC_2N7000
VD5 d5 0 DC 2
VG5 g5 0 DC 6
M6 d6 g6 0 OC_2N7000
VD6 d6 0 DC 5
VG6 g6 0 DC 6
M7 d7 g7 0 OC_2N7000
VD7 d7 0 DC 2
VG7 g7 0 DC 8
M8 d8 g8 0 OC_2N7000
VD8 d8 0 DC 5
VG8 g8 0 DC 8
M9 d9 g9 0 OC_2N7000
VD9 d9 0 DC 2
VG9 g9 0 DC 10
M10 d10 g10 0 OC_2N7000
VD10 d10 0 DC 5
VG10 g10 0 DC 10
.op
.end
