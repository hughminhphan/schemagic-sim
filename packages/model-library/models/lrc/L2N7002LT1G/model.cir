* OpenCircuit Model Factory v0.1.0 bulk adapter
* Original work generated from public factual specifications.
* This model is not copied or adapted from any vendor SPICE model.
* Source: https://jlcpcb.com/api/file/downloadByFileSystemAccessId/8586172828182065152
* Revision: Rev.B Mar 2016
.model OC_LRC_L2N7002LT1G VDMOS( VTO=1.6000000000e0 KP=1.4285714286e0 THETA=0.0000000000e0 LAMBDA=3.0000000000e-3 RD=7.7000000000e-1 RS=2.8000000000e-1 RG=1.0000000000e-4 RDS=1e9 CGS=1.4500000000e-11 CGDMAX=2.5000000000e-12 CGDMIN=2.5000000000e-12 CJO=7.5000000000e-12 IS=1.0000000000e-12 N=1.5000000000e0 RB=2.8000000000e-1)
