Batch 9 independent review: LMBT5401LT1G exact gain hard bounds
* Public datasheet facts only; no vendor SPICE model used.
.model OC_LRC_LMBT5401LT1G PNP(IS=1.0000000000e-14 BF=3.4804588585e2 VAF=1.0000000000e2 IKF=6.0377814707e-2 ISE=6.6093940968e-13 NE=1.5000000000e0 NF=1.0000000000e0 RB=1.0000000000e1 RC=1.0000000000e-1 RE=5.0000000000e-2 CJE=1.0000000000e-12 CJC=1.0000000000e-12 TF=1.0000000000e-9)

.temp 25
VCG1 cg1 0 DC -5
IBG1 0 bg1 DC -1.6785112604330099e-05
QG1 cg1 bg1 0 OC_LRC_LMBT5401LT1G
VCG2 cg2 0 DC -5
IBG2 0 bg2 DC -0.000102840248877078
QG2 cg2 bg2 0 OC_LRC_LMBT5401LT1G
VCG3 cg3 0 DC -5
IBG3 0 bg3 DC -0.0005250151823396
QG3 cg3 bg3 0 OC_LRC_LMBT5401LT1G
.op
.end
