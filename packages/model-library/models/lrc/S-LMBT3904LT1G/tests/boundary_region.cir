OpenCircuit factory test: S-LMBT3904LT1G supported-region upper-current boundary
* OpenCircuit Model Factory v0.1.0 bulk adapter
* Original work generated from public factual specifications.
* This model is not copied or adapted from any vendor SPICE model.
* Source: https://jlcpcb.com/api/file/downloadByFileSystemAccessId/8589838384102608896
* Revision: Rev.B Mar 2016
.model OC_LRC_S-LMBT3904LT1G NPN(IS=4.5755766142e-15 BF=2.7223894119e2 VAF=1.0000000000e2 IKF=8.8120019765e-2 ISE=2.3503235435e-14 NE=1.5000000000e0 NF=1.0000000000e0 RB=1.0000000000e1 RC=1.0000000000e-1 RE=5.0000000000e-2 CJE=1.0000000000e-12 CJC=1.0000000000e-12 TF=1.0000000000e-9)

.temp 25
IC 0 c DC 1.0000000000e-1
IB 0 b DC 9.0909090909e-4
Q1 c b 0 OC_LRC_S-LMBT3904LT1G
.op
.end
