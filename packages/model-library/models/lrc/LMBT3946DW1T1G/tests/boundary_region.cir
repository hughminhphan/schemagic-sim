OpenCircuit factory test: LMBT3946DW1T1G supported-region upper-current boundary
* OpenCircuit Model Factory v0.1.0 bulk adapter
* Original work generated from public factual specifications.
* This model is not copied or adapted from any vendor SPICE model.
* Source: https://jlcpcb.com/api/file/downloadByFileSystemAccessId/8586203794660577280
* Revision: Rev.B Mar 2016
.model OC_LRC_LMBT3946DW1T1G NPN(IS=6.7527523116e-15 BF=3.0771283483e2 VAF=1.0000000000e2 IKF=4.4918934557e-2 ISE=3.6242007992e-14 NE=1.5000000000e0 NF=1.0000000000e0 RB=1.0000000000e1 RC=1.0000000000e-1 RE=5.0000000000e-2 CJE=1.0000000000e-12 CJC=1.0000000000e-12 TF=1.0000000000e-9)

.temp 25
IC 0 c DC 1.0000000000e-1
IB 0 b DC 1.3333333333e-3
Q1 c b 0 OC_LRC_LMBT3946DW1T1G
.op
.end
