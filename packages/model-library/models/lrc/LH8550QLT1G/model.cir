* OpenCircuit Model Factory v0.1.0 bulk adapter
* Original work generated from public factual specifications.
* This model is not copied or adapted from any vendor SPICE model.
* Source: https://jlcpcb.com/api/file/downloadByFileSystemAccessId/8586180226141327360
* Revision: Rev.C
.model OC_LRC_LH8550QLT1G PNP(IS=1.0000000000e-14 BF=2.5313858079e2 VAF=1.0000000000e2 IKF=5.7079434229e-1 ISE=6.5090138866e-15 NE=1.5000000000e0 NF=1.0000000000e0 RB=1.0000000000e1 RC=1.0000000000e-1 RE=5.0000000000e-2 CJE=1.0000000000e-12 CJC=1.0000000000e-12 TF=1.0000000000e-9)
