* OpenCircuit Model Factory v0.1.0 bulk adapter
* Original work generated from public factual specifications.
* This model is not copied or adapted from any vendor SPICE model.
* Source: https://jlcpcb.com/api/file/downloadByFileSystemAccessId/8586172522581151744
* Revision: Rev. O
.model OC_LRC_LBSS138LT1G VDMOS( VTO=1.5000000000e0 KP=6.3492063492e-1 THETA=0.0000000000e0 LAMBDA=3.0000000000e-3 RD=1.7325000000e0 RS=6.3000000000e-1 RG=1.0000000000e-4 RDS=1e9 CGS=3.6500000000e-11 CGDMAX=3.5000000000e-12 CGDMIN=3.5000000000e-12 CJO=8.5000000000e-12 IS=1.0000000000e-12 N=1.5000000000e0 RB=6.3000000000e-1)
