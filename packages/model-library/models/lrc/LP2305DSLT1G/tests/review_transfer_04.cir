OpenCircuit independent F2 residual probe
* OpenCircuit Model Factory v0.1.0 bulk adapter
* Original work generated from public factual specifications.
* This model is not copied or adapted from any vendor SPICE model.
* Source: https://jlcpcb.com/api/file/downloadByFileSystemAccessId/8586189462162313216
* Revision: Rev. A
.model OC_LRC_LP2305DSLT1G VDMOS( pchan VTO=-9.0500883111e-1 KP=3.8230944814e1 THETA=8.0937557816e-11 LAMBDA=9.6786921606e-13 RD=4.6968495926e-2 RS=1.3600000000e-2 RG=1.0000000000e-4 RDS=1e9 CGS=1.0350000000e-9 CGDMAX=2.1000000000e-10 CGDMIN=2.1000000000e-10 CJO=1.6500000000e-10 IS=1.0000000000e-12 N=1.5000000000e0 RB=1.3600000000e-2)
.temp 25
M1 d g 0 OC_LRC_LP2305DSLT1G
VD d 0 DC -5
VG g 0 DC -1.8
.op
.end
