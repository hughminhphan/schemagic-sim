OpenCircuit factory test: LP2305DSLT1G RDS(on)
* OpenCircuit Model Factory v0.1.0 bulk adapter
* Original work generated from public factual specifications.
* This model is not copied or adapted from any vendor SPICE model.
* Source: https://jlcpcb.com/api/file/downloadByFileSystemAccessId/8586189462162313216
* Revision: Rev. A
.model OC_LRC_LP2305DSLT1G VDMOS( pchan VTO=-9.0500883111e-1 KP=3.8230944814e1 THETA=8.0937557816e-11 LAMBDA=9.6786921606e-13 RD=4.6968495926e-2 RS=1.3600000000e-2 RG=1.0000000000e-4 RDS=1e9 CGS=1.0350000000e-9 CGDMAX=2.1000000000e-10 CGDMIN=2.1000000000e-10 CJO=1.6500000000e-10 IS=1.0000000000e-12 N=1.5000000000e0 RB=1.3600000000e-2)

.temp 25
M1 d1 g1 0 OC_LRC_LP2305DSLT1G
ID1 d1 0 DC 3.5000000000e0
VG1 g1 0 DC -4.5000000000e0
M2 d2 g2 0 OC_LRC_LP2305DSLT1G
ID2 d2 0 DC 3.0000000000e0
VG2 g2 0 DC -2.5000000000e0
M3 d3 g3 0 OC_LRC_LP2305DSLT1G
ID3 d3 0 DC 2.0000000000e0
VG3 g3 0 DC -1.8000000000e0
.op
.end
