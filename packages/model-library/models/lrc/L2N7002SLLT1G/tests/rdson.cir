OpenCircuit factory test: L2N7002SLLT1G RDS(on)
* OpenCircuit Model Factory v0.1.0 bulk adapter
* Original work generated from public factual specifications.
* This model is not copied or adapted from any vendor SPICE model.
* Source: https://jlcpcb.com/api/file/downloadByFileSystemAccessId/8603392942124527616
* Revision: Rev.O Sep. 2023
.model OC_LRC_L2N7002SLLT1G VDMOS( VTO=2.0000000000e0 KP=7.1428571429e-1 THETA=0.0000000000e0 LAMBDA=3.0000000000e-3 RD=1.5400000000e0 RS=5.6000000000e-1 RG=1.0000000000e-4 RDS=1e9 CGS=3.0000000000e-11 CGDMAX=5.0000000000e-12 CGDMIN=5.0000000000e-12 CJO=5.0000000000e-12 IS=1.0000000000e-12 N=1.5000000000e0 RB=5.6000000000e-1)

.temp 25
M1 d1 g1 0 OC_LRC_L2N7002SLLT1G
ID1 0 d1 DC 5.0000000000e-1
VG1 g1 0 DC 1.0000000000e1
M2 d2 g2 0 OC_LRC_L2N7002SLLT1G
ID2 0 d2 DC 2.0000000000e-1
VG2 g2 0 DC 4.5000000000e0
.op
.end
