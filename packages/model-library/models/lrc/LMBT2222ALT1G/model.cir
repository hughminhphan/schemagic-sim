* OpenCircuit Model Factory v0.1.0 bulk adapter
* Original work generated from public factual specifications.
* This model is not copied or adapted from any vendor SPICE model.
* Source: https://jlcpcb.com/api/file/downloadByFileSystemAccessId/8586176093502390272
* Revision: Rev.B, Mar 2016
.model OC_LRC_LMBT2222ALT1G NPN(IS=6.5353806604e-15 BF=1.9312848492e2 VAF=1.0000000000e2 IKF=1.0000000000e3 ISE=2.8054057999e-14 NE=1.5000000000e0 NF=1.0000000000e0 RB=1.0000000000e1 RC=1.0000000000e-1 RE=5.0000000000e-2 CJE=1.0000000000e-12 CJC=1.0000000000e-12 TF=1.0000000000e-9)
