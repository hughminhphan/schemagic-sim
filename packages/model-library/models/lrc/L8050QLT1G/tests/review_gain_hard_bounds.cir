Batch 9 independent review: L8050QLT1G exact gain hard bounds
* Public datasheet facts only; no vendor SPICE model used.
.model OC_LRC_L8050QLT1G NPN(IS=1.0000000000e-14 BF=1.9528363887e2 VAF=1.0000000000e2 IKF=9.5686793390e-1 ISE=2.4457444863e-14 NE=1.5000000000e0 NF=1.0000000000e0 RB=1.0000000000e1 RC=1.0000000000e-1 RE=5.0000000000e-2 CJE=1.0000000000e-12 CJC=1.0000000000e-12 TF=1.0000000000e-9)

.temp 25
VCG1 cg1 0 DC 1
IBG1 0 bg1 DC 0.00057643383598999327
QG1 cg1 bg1 0 OC_LRC_L8050QLT1G
.op
.end
