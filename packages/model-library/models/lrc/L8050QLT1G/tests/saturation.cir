OpenCircuit factory test: L8050QLT1G saturation
* OpenCircuit Model Factory v0.1.0 bulk adapter
* Original work generated from public factual specifications.
* This model is not copied or adapted from any vendor SPICE model.
* Source: https://jlcpcb.com/api/file/downloadByFileSystemAccessId/8586178864515330048
* Revision: Rev.O
.model OC_LRC_L8050QLT1G NPN(IS=1.0000000000e-14 BF=1.9528363887e2 VAF=1.0000000000e2 IKF=9.5686793390e-1 ISE=2.4457444863e-14 NE=1.5000000000e0 NF=1.0000000000e0 RB=1.0000000000e1 RC=1.0000000000e-1 RE=5.0000000000e-2 CJE=1.0000000000e-12 CJC=1.0000000000e-12 TF=1.0000000000e-9)

.temp 25
ICS1 0 cs1 DC 8.0000000000e-1
IBS1 0 bs1 DC 8.0000000000e-2
QS1 cs1 bs1 0 OC_LRC_L8050QLT1G
.op
.end
