OpenCircuit factory test: LMBT3906LT1G supported-region upper-current boundary
* OpenCircuit Model Factory v0.1.0 bulk adapter
* Original work generated from public factual specifications.
* This model is not copied or adapted from any vendor SPICE model.
* Source: https://jlcpcb.com/api/file/downloadByFileSystemAccessId/8586171783624478720
* Revision: Rev. O
.model OC_LRC_LMBT3906LT1G PNP(IS=1.0000000000e-14 BF=1.0000000000e2 VAF=1.0000000000e2 IKF=1.0000000000e3 RB=1.0000000000e1 RC=1.0000000000e-1 RE=5.0000000000e-2 CJE=1.0000000000e-12 CJC=1.0000000000e-12 TF=1.0000000000e-9)

.temp 25
IC 0 c DC -1.0000000000e-1
IB 0 b DC -3.3333333333e-3
Q1 c b 0 OC_LRC_LMBT3906LT1G
.op
.end
