OpenCircuit factory test: ST3422A RDS(on)
* OpenCircuit Model Factory v0.1.0 bulk adapter
* Original work generated from public factual specifications.
* This model is not copied or adapted from any vendor SPICE model.
* Source: https://jlcpcb.com/api/file/downloadByFileSystemAccessId/8588907496194904064
* Revision: STN3422A 2009. V1
.model OC_STANSON-TECH_ST3422A VDMOS( VTO=3.0000000000e0 KP=7.1428571429e1 THETA=0.0000000000e0 LAMBDA=3.0000000000e-3 RD=1.5400000000e-2 RS=5.6000000000e-3 RG=1.0000000000e-4 RDS=1e9 CGS=4.1700000000e-10 CGDMAX=3.8000000000e-11 CGDMIN=3.8000000000e-11 CJO=2.0500000000e-10 IS=1.0000000000e-12 N=1.5000000000e0 RB=5.6000000000e-3)

.temp 25
M1 d1 g1 0 OC_STANSON-TECH_ST3422A
ID1 0 d1 DC 6.0000000000e0
VG1 g1 0 DC 1.0000000000e1
M2 d2 g2 0 OC_STANSON-TECH_ST3422A
ID2 0 d2 DC 6.0000000000e0
VG2 g2 0 DC 1.0000000000e1
M3 d3 g3 0 OC_STANSON-TECH_ST3422A
ID3 0 d3 DC 2.5000000000e0
VG3 g3 0 DC 4.5000000000e0
M4 d4 g4 0 OC_STANSON-TECH_ST3422A
ID4 0 d4 DC 2.5000000000e0
VG4 g4 0 DC 4.5000000000e0
.op
.end
