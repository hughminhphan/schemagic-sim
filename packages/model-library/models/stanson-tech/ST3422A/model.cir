* OpenCircuit Model Factory v0.1.0 bulk adapter
* Original work generated from public factual specifications.
* This model is not copied or adapted from any vendor SPICE model.
* Source: https://jlcpcb.com/api/file/downloadByFileSystemAccessId/8588907496194904064
* Revision: STN3422A 2009. V1
.model OC_STANSON-TECH_ST3422A VDMOS( VTO=3.0000000000e0 KP=7.1428571429e1 THETA=0.0000000000e0 LAMBDA=3.0000000000e-3 RD=1.5400000000e-2 RS=5.6000000000e-3 RG=1.0000000000e-4 RDS=1e9 CGS=4.1700000000e-10 CGDMAX=3.8000000000e-11 CGDMIN=3.8000000000e-11 CJO=2.0500000000e-10 IS=1.0000000000e-12 N=1.5000000000e0 RB=5.6000000000e-3)
