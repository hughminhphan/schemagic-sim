* OpenCircuit Model Factory v0.1.0 bulk adapter
* Original work generated from public factual specifications.
* This model is not copied or adapted from any vendor SPICE model.
* Source: https://jlcpcb.com/api/file/downloadByFileSystemAccessId/8603406425536143360
* Revision: Rev.-2.0
.model OC_YONGYUTAI_CD4148WSP D(IS=1.7528431166e-9 N=1.8000000000e0 RS=1.0000000000e-4)
