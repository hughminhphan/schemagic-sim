* OpenCircuit Model Factory v0.1.0 bulk adapter
* Original work generated from public factual specifications.
* This model is not copied or adapted from any vendor SPICE model.
* Source: https://jlcpcb.com/api/file/downloadByFileSystemAccessId/8588903912976236544
* Revision: Not stated in the supplied datasheet
.model OC_KEXIN_IRLML6401 VDMOS( pchan VTO=-5.5000000000e-1 KP=4.0000000000e1 THETA=0.0000000000e0 LAMBDA=3.0000000000e-3 RD=2.7500000000e-2 RS=1.0000000000e-2 RG=1.0000000000e-4 RDS=1e9 CGS=7.0500000000e-10 CGDMAX=1.2500000000e-10 CGDMIN=1.2500000000e-10 CJO=5.5000000000e-11 IS=1.0000000000e-12 N=1.5000000000e0 RB=1.0000000000e-2)
