OpenCircuit factory test: TM15N06SI RDS(on)
* OpenCircuit Model Factory v0.1.0 bulk adapter
* Original work generated from public factual specifications.
* This model is not copied or adapted from any vendor SPICE model.
* Source: https://jlcpcb.com/api/file/downloadByFileSystemAccessId/8590903799635009536
* Revision: 2018 datasheet; supplied PDF
.model OC_TRITECH-MOS_TM15N06SI VDMOS( VTO=1.6000000000e0 KP=6.6666666667e1 THETA=0.0000000000e0 LAMBDA=3.0000000000e-3 RD=1.6500000000e-2 RS=6.0000000000e-3 RG=1.0000000000e-4 RDS=1e9 CGS=1.0986000000e-9 CGDMAX=4.9400000000e-11 CGDMIN=4.9400000000e-11 CJO=9.1000000000e-12 IS=1.0000000000e-12 N=1.5000000000e0 RB=6.0000000000e-3)

.temp 25
M1 d1 g1 0 OC_TRITECH-MOS_TM15N06SI
ID1 0 d1 DC 5.0000000000e0
VG1 g1 0 DC 1.0000000000e1
.op
.end
