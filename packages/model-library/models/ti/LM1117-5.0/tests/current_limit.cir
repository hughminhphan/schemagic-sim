* LM1117-5.0 current limit at the datasheet bias
* OpenCircuit Model Factory v0.1.0
* Original work generated from public factual specifications.
* LM1117-5.0 (Texas Instruments), datasheet SNOS412Q, February 2000, revised January 2023, fitted 2026-08-07
* Archetype: archetype-vreg.md, variant FIXED. Manual run: R1-regulators-2026-08-07
* Node order: IN OUT GND
.subckt OC_LM1117_5_0 IN OUT GND
+ PARAMS: VREF=5 VDROP=1.2 ILIM=1.2 LOADREG=0.001 DILOAD=0.8
+ LINEREG=0.001 DVLINE=8.5 VNOM=7 IQ=0.005 RNEG=1 EPS=1e-8
BTGT tgt GND V = VREF + (LINEREG/DVLINE)*(v(IN,GND)-VNOM)
BHDR hdr GND V = v(IN,GND) - VDROP
BSEL sel GND V = 0.5*(v(tgt)+v(hdr)) - 0.5*sqrt((v(tgt)-v(hdr))*(v(tgt)-v(hdr))+EPS)
BERR er GND V = 0.5*((v(sel)-v(OUT,GND)) + sqrt((v(sel)-v(OUT,GND))*(v(sel)-v(OUT,GND))+EPS))
RER er GND 1meg
BPASS IN OUT I = ILIM*tanh({DILOAD/LOADREG}/ILIM*v(er))
RSER OUT GND 1e7
DNEG GND OUT DCLAMP_LM1117_5_0
IQD IN GND DC {IQ}
.model DCLAMP_LM1117_5_0 D(IS=1e-12 N=1 RS={RNEG})
.ends OC_LM1117_5_0
.temp 25
VIN in 0 DC 5
X1 in out 0 OC_LM1117_5_0
VSHORT out 0 DC 0
.op
.end
