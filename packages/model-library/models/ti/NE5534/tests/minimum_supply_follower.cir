OpenCircuit factory test: NE5534 minimum rated supply follower
* OpenCircuit Model Factory v0.1.0
* Original work generated from public factual specifications.
* This model is not a copy of, or adaptation from, any vendor SPICE model.
* Source: https://www.ti.com/lit/ds/symlink/ne5534.pdf
* Revision: SLOS070D, July 1979, revised November 2014
* Fit: exactly three native ngspice-46 fixed-point calibration iterations
* Node order: INP INN VCC VEE OUT
.subckt OC_TI_NE5534 INP INN VCC VEE OUT
.param AOL=1.0000000000e5 GBW=1.5317131854e7 SR=1.3439713151e7 IBIAS=5.0000000000e-7 IOS=2.0000000000e-8 VOS=5.0000000000e-4
.param ROUT=3.0000000000e-1 ILIM=3.8000000000e-2 VDRP_H=1.9996100713e0 VDRP_L=1.9996097771e0 CC=30p FP2=8.8433501993e6
.param CMRR=1.0000000000e5 PSRR=1.0000000000e5 VSUP_NOM=3.0000000000e1 IQ=4.0000000000e-3 EN=4.0000000000e-9
IBP 0 INP DC {IBIAS+IOS/2}
IBN 0 INN DC {IBIAS-IOS/2}
CDIF INP INN 1p
BERR e 0 V = v(INP,INN) + VOS + v(nz) + 0.5*(v(INP)+v(INN))/CMRR + (v(VCC,VEE)-VSUP_NOM)/PSRR
RE e 0 1meg
RNZ nz 0 {EN*EN/(4*1.380649e-23*300.15)}
BGM 0 p I = {SR*CC}*tanh({6.283185307*GBW/SR}*v(e))
CP p 0 {CC}
RP p 0 {AOL/(6.283185307*GBW*CC)}
RP2 p p2 {1/(6.283185307*FP2*1p)}
CP2 p2 0 1p
BCLMP q 0 V = min(max(v(p2), v(VEE)+min(VDRP_L,0.49*v(VCC,VEE))), v(VCC)-min(VDRP_H,0.49*v(VCC,VEE)))
RQ q 0 1meg
BOUT 0 OUT I = ILIM*tanh((v(q)-v(OUT))/(ROUT*ILIM))
IQVCC VCC VEE DC {IQ}
.ends OC_TI_NE5534

.temp 25
VCC vcc 0 DC 3.0000000000e0
VEE vee 0 DC -3.0000000000e0
VINN inn_sig 0 DC -0.25
XN inn_sig outn vcc vee outn OC_TI_NE5534
RLN outn 0 10k
VINZ zero_sig 0 DC 0
XZ zero_sig outz vcc vee outz OC_TI_NE5534
RLZ outz 0 10k
VINP inp_sig 0 DC 0.25
XP inp_sig outp vcc vee outp OC_TI_NE5534
RLP outp 0 10k
.op
.end
