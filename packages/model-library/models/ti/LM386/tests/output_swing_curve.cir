OpenCircuit factory test: LM386 cited output-swing curve
* OpenCircuit Model Factory v0.1.0
* Original work generated from public factual specifications.
* This model is not a copy of, or adaptation from, any vendor SPICE model.
* Source: https://www.ti.com/lit/ds/symlink/lm386.pdf
* Revision: SNAS545D, May 2004, revised August 2023
* Fit: native ngspice-46 least-squares fit to cited frequency-response and output-swing curves
* Node order: GAIN1 INN INP GND OUT VS BYPASS GAIN8
.subckt OC_TI_LM386 GAIN1 INN INP GND OUT VS BYPASS GAIN8 params: GAIN_CL=1.9879183508e1
.param GAIN_OPEN=1.9879183508e1 BW=3.0032545580e5 VDROP=9.1480329475e-1 ILIM=5.1709420977e-1
.param ROUT=5.0000000000e-1 IQ=4.0000000000e-3 IBIAS=2.5000000000e-7 RIN=5.0000000000e4 RBYP=1.5000000000e4 RGAIN=1.5000000000e3
RINPUT INP INN {RIN}
IBP GND INP DC {IBIAS}
IBN GND INN DC {IBIAS}
RBP1 VS BYPASS {RBYP}
RBP2 BYPASS GND {RBYP}
RG12 GAIN1 GAIN8 {RGAIN}
RG1DC GAIN1 GND 1G
RG8DC GAIN8 GND 1G
BIDEAL pre GND V={v(GND)+0.5*v(VS,GND)+GAIN_CL*v(INP,INN)}
RLP pre filt 1k
CLP filt GND {1/(6.283185307*BW*1k)}
BCLAMP q GND V={min(max(v(filt),v(GND)+VDROP),v(VS)-VDROP)}
RQ q GND 1G
BOUT GND OUT I={ILIM*tanh((v(q)-v(OUT))/(ROUT*ILIM))}
IQDRAW VS GND DC {IQ}
.ends OC_TI_LM386

VS1 vs1 0 DC 4
VM1 mid1 0 DC 2
VIN1 inp1 0 DC 1
X1 g1_1 0 inp1 0 out1 vs1 byp1 g8_1 OC_TI_LM386
RL1 out1 mid1 8
VS2 vs2 0 DC 6
VM2 mid2 0 DC 3
VIN2 inp2 0 DC 1
X2 g1_2 0 inp2 0 out2 vs2 byp2 g8_2 OC_TI_LM386
RL2 out2 mid2 8
VS3 vs3 0 DC 8
VM3 mid3 0 DC 4
VIN3 inp3 0 DC 1
X3 g1_3 0 inp3 0 out3 vs3 byp3 g8_3 OC_TI_LM386
RL3 out3 mid3 8
VS4 vs4 0 DC 10
VM4 mid4 0 DC 5
VIN4 inp4 0 DC 1
X4 g1_4 0 inp4 0 out4 vs4 byp4 g8_4 OC_TI_LM386
RL4 out4 mid4 8
VS5 vs5 0 DC 12
VM5 mid5 0 DC 6
VIN5 inp5 0 DC 1
X5 g1_5 0 inp5 0 out5 vs5 byp5 g8_5 OC_TI_LM386
RL5 out5 mid5 8
.op
.end
