OpenCircuit LMV358 offset bias and supply current
* OpenCircuit Model Factory v0.1.0
* Original work generated from public factual specifications.
* This model is not a copy of, or adaptation from, any vendor SPICE model.
* Node order: INP INN VCC VEE OUT
.subckt OC_TI_LMV358 INP INN VCC VEE OUT
.param AOL=1.0000000000e+05 GBW=1.5318237359e+06 SR=1.0380343703e+06 IBIAS=1.5000000000e-08 IOS=5.0000000000e-09 VOS=1.7000000000e-03
.param ROUT=1.0000000000e+00 ILIM=4.0000000000e-02 VDRP_H=3.8789719456e-02 VDRP_L=1.1878961984e-01 CC=30p FP2=8.8439884627e+05
.param CMRR=1.7782794100e+03 PSRR=1.0000000000e+03 VSUP_NOM=5.0000000000e+00 IQ=1.0500000000e-04 EN=3.9000000000e-08
IBP 0 INP DC {IBIAS+IOS/2}
IBN 0 INN DC {IBIAS-IOS/2}
CDIF INP INN 1p
BERR e 0 V = v(INP,INN) + VOS + v(nz) + 0.5*(v(INP)+v(INN))/CMRR + (v(VCC,VEE)-VSUP_NOM)/PSRR
RE e 0 1meg
RNZ nz 0 {EN*EN/(4*1.380649e-23*300.15)}
BGM 0 p I = {SR*CC}*tanh({6.283185307*GBW/SR}*v(e))
CP p 0 {CC}
RP p 0 {AOL/(6.283185307*GBW*CC)}
RP2 p p2 {1/(6.283185307*FP2*1p)}
CP2 p2 0 1p
BCLMP q 0 V = min(max(v(p2), v(VEE)+min(VDRP_L,0.49*v(VCC,VEE))), v(VCC)-min(VDRP_H,0.49*v(VCC,VEE)))
RQ q 0 1meg
BOUT 0 OUT I = ILIM*tanh((v(q)-v(OUT))/(ROUT*ILIM))
IQVCC VCC VEE DC {IQ}
.ends OC_TI_LMV358

.temp 25
VCC vcc 0 DC 5
VEE vee 0 DC 0
VMID mid 0 DC 2.5
XOFF mid off vcc vee off OC_TI_LMV358
RLOFF off mid 10k
XBIAS p n vcc vee ob OC_TI_LMV358
VP p mid DC 0
VN n mid DC 0
RLB ob mid 2k
.op
.end
