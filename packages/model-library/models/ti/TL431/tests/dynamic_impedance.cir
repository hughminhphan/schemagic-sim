* TL431 low-frequency dynamic impedance at the stated 1 mA bias
* OpenCircuit Model Factory v0.1.0
* Original work generated from public factual specifications.
* TL431 (Texas Instruments), datasheet SLVS543S, August 2004, revised May 2024, fitted 2026-08-07
* Archetype: archetype-vreg.md, variant SHUNT. Manual run: R1-regulators-2026-08-07
* Node order: K A REF
.subckt OC_TL431 K A REF
+ PARAMS: VREF=2.495 IKMIN=0.0004 IKMAX=0.15 ZKA=0.2
BK K A I = IKMIN + (IKMAX-IKMIN)*tanh({1/(ZKA*(IKMAX-IKMIN))}*0.5*((v(REF,A)-VREF)+sqrt((v(REF,A)-VREF)*(v(REF,A)-VREF)+1e-12)))
RKA K A 1e7
.ends OC_TL431
.temp 25
IBIAS 0 k DC 0.001 AC 0.0001
X1 k 0 k OC_TL431
.ac lin 1 120 120
.end
