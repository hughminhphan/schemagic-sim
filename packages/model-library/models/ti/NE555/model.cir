* OpenCircuit model factory generated model
* Original work generated from public factual specifications only
* No vendor SPICE model text was used
* NE555 (Texas Instruments), datasheet SLFS022K, September 1973, revised March 2026, fitted 2026-08-07
* Archetype: archetype-timer555.md
* Node order: GND TRIG OUT RESET CONT THRES DISCH VCC (DIP-8 pins 1 through 8)
.subckt OC_NE555 GND TRIG OUT RESET CONT THRES DISCH VCC
+ PARAMS: RDIV=5000 AGAIN=2e3 KREG=25 TAU=20n VDRP_H=0.0333333333 VDRP_L=0.0166666667
+ RDIS=18.75 RDOFF=1e9 KSW=20 ROUT=16.6666667 VSKEW=0.05 VRESET=0.7 IQ=0.003
RA VCC CONT {RDIV}
RB CONT CTRG {RDIV}
RC CTRG GND {RDIV}
BCU cu GND V = 0.5*(1+tanh(AGAIN*(v(THRES,GND)-v(CONT,GND))))
RCU cu GND 1meg
BCL cl GND V = 0.5*(1+tanh(AGAIN*(v(CTRG,GND)-v(TRIG,GND))))
RCL cl GND 1meg
BRS rs GND V = 0.5*(1+tanh(20*(v(RESET,GND)-VRESET)))
RRS rs GND 1meg
BQA qad GND V = v(rs)*( (v(cu)>0.5) ? 0 : ( (v(cl)>0.5) ? 1 : 0.5*(1-tanh(KREG*(v(qb)-0.5))) ) )
RQA qad qa {TAU/1p}
CQA qa GND 1p
BQB qbd GND V = 0.5*(1-tanh(KREG*(v(qa)-0.5))) + VSKEW
RQB qbd qb {TAU/1p}
CQB qb GND 1p
BOUT od GND V = min(max(VDRP_L + (v(VCC,GND)-VDRP_H-VDRP_L)*v(qa), 0), v(VCC,GND))
ROUT od OUT {ROUT}
RDISCH DISCH GND R={1/((1/RDIS)*0.5*(1-tanh(KSW*(v(qa)-0.5))) + 1/RDOFF)}
IQD VCC GND DC {IQ}
.ends OC_NE555
