OpenCircuit factory test: LM741 cmrr.cir
* OpenCircuit Model Factory v0.1.0
* Original work generated from public factual specifications.
* This model is not a copy of, or adaptation from, any vendor SPICE model.
* Source: https://www.ti.com/lit/ds/symlink/lm741.pdf
* Revision: SNOSC25D, May 1998, revised October 2015
* Fit: exactly three native ngspice-46 fixed-point calibration iterations
* Node order: INP INN VCC VEE OUT
.subckt OC_TI_LM741 INP INN VCC VEE OUT
.param AOL=2.0000000000e5 GBW=1.0983900156e6 SR=5.2725145747e5 IBIAS=8.0000000000e-8 IOS=2.0000000000e-8 VOS=1.0000000000e-3
.param ROUT=4.0000000000e1 ILIM=2.5000000000e-2 VDRP_H=9.4394415985e-1 VDRP_L=9.4394814588e-1 CC=30p FP2=3.2951700467e6
.param CMRR=5.6234132519e4 PSRR=6.3095734448e4 VSUP_NOM=3.0000000000e1 IQ=1.7000000000e-3
IBP 0 INP DC {IBIAS+IOS/2}
IBN 0 INN DC {IBIAS-IOS/2}
CDIF INP INN 1p
BERR e 0 V = v(INP,INN) + VOS + 0.5*(v(INP)+v(INN))/CMRR + (v(VCC,VEE)-VSUP_NOM)/PSRR
RE e 0 1meg
BGM 0 p I = {SR*CC}*tanh({6.283185307*GBW/SR}*v(e))
CP p 0 {CC}
RP p 0 {AOL/(6.283185307*GBW*CC)}
RP2 p p2 {1/(6.283185307*FP2*1p)}
CP2 p2 0 1p
BCLMP q 0 V = min(max(v(p2), v(VEE)+min(VDRP_L,0.49*v(VCC,VEE))), v(VCC)-min(VDRP_H,0.49*v(VCC,VEE)))
RQ q 0 1meg
BOUT 0 OUT I = ILIM*tanh((v(q)-v(OUT))/(ROUT*ILIM))
IQVCC VCC VEE DC {IQ}
.ends OC_TI_LM741

.temp 25
VCC vcc 0 DC 15
VEE vee 0 DC -15
VCM sig 0 DC 12 AC 1
X1 sig inn vcc vee out OC_TI_LM741
LSERVO out inn 1G
CSERVO inn sig 1G
RL out 0 2k
.ac lin 1 0.01 0.01
.end
