OpenCircuit factory test: LM13700 cited transconductance curve
* OpenCircuit Model Factory v0.1.0
* Original work generated from public factual specifications.
* This model is not a copy of, or adaptation from, any vendor SPICE model.
* Source: https://www.ti.com/lit/ds/symlink/lm13700.pdf
* Revision: SNOSBW2F, November 1999, revised November 2015
* Fit: native ngspice-46 least-squares fit to cited transconductance and amplifier-bias curves
* Node order follows physical pins 1 through 16
.subckt OC_TI_LM13700 IABC1 DIODE1 INP1 INN1 OUT1 VEE BUFIN1 BUFOUT1 BUFOUT2 BUFIN2 VCC OUT2 INN2 INP2 DIODE2 IABC2
.param GM_SCALE=9.9007129703e-1 VT=2.6000000000e-2 POLE_HZ=2.0000000000e6 VBIAS0=1.2823117214e0 RABC=2.7333161059e2
.param RIN=2.6000000000e4 ROUT=2.0000000000e6 IQ=2.6000000000e-3 VBUF_DROP=1.2000000000e0 RBUF=2.5000000000e1 ILIM_BUF=2.0000000000e-2 IBUF=5.0000000000e-7
VB1 IABC1 NABC1 DC {VBIAS0}
RABC1 NABC1 VEE {RABC}
VB2 IABC2 NABC2 DC {VBIAS0}
RABC2 NABC2 VEE {RABC}
RIN1 INP1 INN1 {RIN}
RIN2 INP2 INN2 {RIN}
RIP1 INP1 0 1G
RIN1DC INN1 0 1G
RIP2 INP2 0 1G
RIN2DC INN2 0 1G
RD1DC DIODE1 0 1G
RD2DC DIODE2 0 1G
RBI1DC BUFIN1 0 1G
RBO1DC BUFOUT1 0 1G
RBI2DC BUFIN2 0 1G
RBO2DC BUFOUT2 0 1G
BGM1 VEE NGM1 I={GM_SCALE*max((v(IABC1,VEE)-VBIAS0)/RABC,0)*tanh(v(INP1,INN1)/(2*VT))}
RPOLE1 NGM1 VEE 1
CPOLE1 NGM1 VEE {1/(6.283185307*POLE_HZ)}
BOUT1 VEE OUT1 I={v(NGM1,VEE)}
ROUT1 OUT1 0 {ROUT}
BGM2 VEE NGM2 I={GM_SCALE*max((v(IABC2,VEE)-VBIAS0)/RABC,0)*tanh(v(INP2,INN2)/(2*VT))}
RPOLE2 NGM2 VEE 1
CPOLE2 NGM2 VEE {1/(6.283185307*POLE_HZ)}
BOUT2 VEE OUT2 I={v(NGM2,VEE)}
ROUT2 OUT2 0 {ROUT}
DLI1P DIODE1 INP1 DLIN
DLI1N DIODE1 INN1 DLIN
DLI2P DIODE2 INP2 DLIN
DLI2N DIODE2 INN2 DLIN
.model DLIN D(IS=1e-14 N=1)
IBUF1 BUFIN1 VEE DC {IBUF}
BBUF1 NBF1 0 V={min(max(v(BUFIN1)-VBUF_DROP,v(VEE)+VBUF_DROP),v(VCC)-VBUF_DROP)}
BBO1 VEE BUFOUT1 I={ILIM_BUF*tanh((v(NBF1)-v(BUFOUT1))/(RBUF*ILIM_BUF))}
IBUF2 BUFIN2 VEE DC {IBUF}
BBUF2 NBF2 0 V={min(max(v(BUFIN2)-VBUF_DROP,v(VEE)+VBUF_DROP),v(VCC)-VBUF_DROP)}
BBO2 VEE BUFOUT2 I={ILIM_BUF*tanh((v(NBF2)-v(BUFOUT2))/(RBUF*ILIM_BUF))}
IQDRAW VCC VEE DC {IQ}
.ends OC_TI_LM13700

VCC vcc 0 DC 15
VEE vee 0 DC -15
IABC1 vcc abc1 DC 0.000001
VIN1 inp1 0 DC 0 AC 1m
VNN1 inn1 0 DC 0
VOUT1 out1 0 DC 0
X1 abc1 d1_1 inp1 inn1 out1 vee bi1_1 bo1_1 bo2_1 bi2_1 vcc o2_1 n2_1 p2_1 d2_1 a2_1 OC_TI_LM13700
IABC2 vcc abc2 DC 0.00001
VIN2 inp2 0 DC 0 AC 1m
VNN2 inn2 0 DC 0
VOUT2 out2 0 DC 0
X2 abc2 d1_2 inp2 inn2 out2 vee bi1_2 bo1_2 bo2_2 bi2_2 vcc o2_2 n2_2 p2_2 d2_2 a2_2 OC_TI_LM13700
IABC3 vcc abc3 DC 0.0001
VIN3 inp3 0 DC 0 AC 1m
VNN3 inn3 0 DC 0
VOUT3 out3 0 DC 0
X3 abc3 d1_3 inp3 inn3 out3 vee bi1_3 bo1_3 bo2_3 bi2_3 vcc o2_3 n2_3 p2_3 d2_3 a2_3 OC_TI_LM13700
IABC4 vcc abc4 DC 0.0005
VIN4 inp4 0 DC 0 AC 1m
VNN4 inn4 0 DC 0
VOUT4 out4 0 DC 0
X4 abc4 d1_4 inp4 inn4 out4 vee bi1_4 bo1_4 bo2_4 bi2_4 vcc o2_4 n2_4 p2_4 d2_4 a2_4 OC_TI_LM13700
IABC5 vcc abc5 DC 0.001
VIN5 inp5 0 DC 0 AC 1m
VNN5 inn5 0 DC 0
VOUT5 out5 0 DC 0
X5 abc5 d1_5 inp5 inn5 out5 vee bi1_5 bo1_5 bo2_5 bi2_5 vcc o2_5 n2_5 p2_5 d2_5 a2_5 OC_TI_LM13700
.ac lin 1 10 10
.end
