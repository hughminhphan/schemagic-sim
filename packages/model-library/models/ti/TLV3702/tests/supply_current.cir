TLV3702 quiescent supply current
* OpenCircuit Model Factory v0.1.0
* Original work generated from public factual specifications.
* This model is not a copy of, or adaptation from, any vendor SPICE model.
* Source: https://www.ti.com/lit/ds/symlink/tlv3702.pdf
* Revision: SLCS137E, November 2000, revised December 2025
* Archetype: archetype-comparator.md, variant PP
* Fit: exactly three native ngspice-46 fixed-point calibration iterations
* Node order: INP INN OUT VCC GND
.subckt OC_TLV3702 INP INN OUT VCC GND
+ PARAMS: AOL=1.0000000000e06 VOS=-2.5000000000e-04 IBIAS=8.0000000000e-11 IOS=2.0000000000e-11 TPD=1.6607653044e-05
+ VCLAMP=1 KSW=20 VHYST=1.4000000000e-03 IQ=5.6000000000e-07 CD=10p
IBP GND INP DC {IBIAS+IOS/2}
IBN GND INN DC {IBIAS-IOS/2}
CDIF INP INN 1p
BC c GND V = VCLAMP*tanh((AOL/VCLAMP)*(v(INP,INN)+VOS+VHYST*v(cd)/VCLAMP))
RC c cd {TPD/0.693/CD}
CC cd GND {CD}
BQ q GND V = 8.0000000000e-02 + (v(VCC,GND)-8.0000000000e-02-8.0000000000e-02)*0.5*(1+tanh(KSW*v(cd)/VCLAMP))
RQ q GND 1meg
BOUT GND OUT I = 6.0000000000e-05*tanh((v(q)-v(OUT,GND))/(4.0000000000e04*6.0000000000e-05))
IQD VCC GND DC {IQ}
.ends OC_TLV3702
.temp 25
VCC vcc 0 5
VREF ref 0 2.5
VIN sig 0 2.4
X1 sig ref out vcc 0 OC_TLV3702
.op
.end
