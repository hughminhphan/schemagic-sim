* OpenCircuit Model Factory v0.1.0 bulk adapter
* Original work generated from public factual specifications.
* This model is not copied or adapted from any vendor SPICE model.
* Source: https://jlcpcb.com/api/file/downloadByFileSystemAccessId/8586188417181237248
* Revision: Rev.2.0 (2017-11-30)
.model OC_TOSHIBA_T2N7002BK-LM VDMOS( VTO=2.1000000000e0 KP=1.9047619048e0 THETA=0.0000000000e0 LAMBDA=3.0000000000e-3 RD=5.7750000000e-1 RS=2.1000000000e-1 RG=1.0000000000e-4 RDS=1e9 CGS=2.4700000000e-11 CGDMAX=1.3000000000e-12 CGDMIN=1.3000000000e-12 CJO=4.2000000000e-12 IS=1.0000000000e-12 N=1.5000000000e0 RB=2.1000000000e-1)
