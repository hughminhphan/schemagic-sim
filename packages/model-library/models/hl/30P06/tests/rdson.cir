OpenCircuit factory test: 30P06 RDS(on)
* OpenCircuit Model Factory v0.1.0 bulk adapter
* Original work generated from public factual specifications.
* This model is not copied or adapted from any vendor SPICE model.
* Source: https://jlcpcb.com/api/file/downloadByFileSystemAccessId/8590910825551523840
* Revision: Version 1.1
.model OC_HL_30P06 VDMOS( pchan VTO=-1.8000000000e0 KP=8.3333333333e1 THETA=0.0000000000e0 LAMBDA=3.0000000000e-3 RD=1.3200000000e-2 RS=4.8000000000e-3 RG=1.0000000000e-4 RDS=1e9 CGS=3.9280000000e-9 CGDMAX=9.8000000000e-11 CGDMIN=9.8000000000e-11 CJO=3.6000000000e-11 IS=1.0000000000e-12 N=1.5000000000e0 RB=4.8000000000e-3)

.temp 25
M1 d1 g1 0 OC_HL_30P06
ID1 d1 0 DC 1.0000000000e1
VG1 g1 0 DC -1.0000000000e1
.op
.end
