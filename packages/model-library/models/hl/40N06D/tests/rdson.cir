OpenCircuit factory test: 40N06D RDS(on)
* OpenCircuit Model Factory v0.1.0 bulk adapter
* Original work generated from public factual specifications.
* This model is not copied or adapted from any vendor SPICE model.
* Source: https://jlcpcb.com/api/file/downloadByFileSystemAccessId/8590908001924558848
* Revision: Not stated in the supplied datasheet
.model OC_HL_40N06D VDMOS( VTO=1.6000000000e0 KP=1.6666666667e2 THETA=0.0000000000e0 LAMBDA=3.0000000000e-3 RD=6.6000000000e-3 RS=2.4000000000e-3 RG=1.0000000000e-4 RDS=1e9 CGS=2.7800000000e-9 CGDMAX=1.2000000000e-10 CGDMIN=1.2000000000e-10 CJO=2.0000000000e-11 IS=1.0000000000e-12 N=1.5000000000e0 RB=2.4000000000e-3)

.temp 25
M1 d1 g1 0 OC_HL_40N06D
ID1 0 d1 DC 3.0000000000e1
VG1 g1 0 DC 1.0000000000e1
M2 d2 g2 0 OC_HL_40N06D
ID2 0 d2 DC 3.0000000000e1
VG2 g2 0 DC 1.0000000000e1
M3 d3 g3 0 OC_HL_40N06D
ID3 0 d3 DC 2.0000000000e1
VG3 g3 0 DC 4.5000000000e0
M4 d4 g4 0 OC_HL_40N06D
ID4 0 d4 DC 2.0000000000e1
VG4 g4 0 DC 4.5000000000e0
.op
.end
