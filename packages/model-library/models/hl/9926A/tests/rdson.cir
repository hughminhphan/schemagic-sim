OpenCircuit factory test: 9926A RDS(on)
* OpenCircuit Model Factory v0.1.0 bulk adapter
* Original work generated from public factual specifications.
* This model is not copied or adapted from any vendor SPICE model.
* Source: https://jlcpcb.com/api/file/downloadByFileSystemAccessId/8603003562100342784
* Revision: Not stated in datasheet
.model OC_HL_9926A VDMOS( VTO=7.0000000000e-1 KP=1.0000000000e2 THETA=0.0000000000e0 LAMBDA=3.0000000000e-3 RD=1.1000000000e-2 RS=4.0000000000e-3 RG=1.0000000000e-4 RDS=1e9 CGS=2.9950000000e-10 CGDMAX=5.8500000000e-11 CGDMIN=5.8500000000e-11 CJO=1.0800000000e-11 IS=1.0000000000e-12 N=1.5000000000e0 RB=4.0000000000e-3)

.temp 25
M1 d1 g1 0 OC_HL_9926A
ID1 0 d1 DC 6.0000000000e0
VG1 g1 0 DC 4.5000000000e0
.op
.end
