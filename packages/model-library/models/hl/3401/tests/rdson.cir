OpenCircuit factory test: 3401 RDS(on)
* OpenCircuit Model Factory v0.1.0 bulk adapter
* Original work generated from public factual specifications.
* This model is not copied or adapted from any vendor SPICE model.
* Source: https://jlcpcb.com/api/file/downloadByFileSystemAccessId/8590907626752454656
* Revision: not stated; document carries no revision or date marking
.model OC_HL_3401 VDMOS( pchan VTO=-9.5000000000e-1 KP=4.1666666667e1 THETA=0.0000000000e0 LAMBDA=3.0000000000e-3 RD=2.6400000000e-2 RS=9.6000000000e-3 RG=1.0000000000e-4 RDS=1e9 CGS=5.1800000000e-10 CGDMAX=3.5000000000e-11 CGDMIN=3.5000000000e-11 CJO=2.2000000000e-11 IS=1.0000000000e-12 N=1.5000000000e0 RB=9.6000000000e-3)

.temp 25
M1 d1 g1 0 OC_HL_3401
ID1 d1 0 DC 4.0000000000e0
VG1 g1 0 DC -1.0000000000e1
.op
.end
