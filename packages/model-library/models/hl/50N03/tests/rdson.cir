OpenCircuit factory test: 50N03 RDS(on)
* OpenCircuit Model Factory v0.1.0 bulk adapter
* Original work generated from public factual specifications.
* This model is not copied or adapted from any vendor SPICE model.
* Source: https://jlcpcb.com/api/file/downloadByFileSystemAccessId/8590922997559738368
* Revision: Not stated in supplied PDF
.model OC_HL_50N03 VDMOS( VTO=1.5000000000e0 KP=2.6315789474e2 THETA=0.0000000000e0 LAMBDA=3.0000000000e-3 RD=4.1800000000e-3 RS=1.5200000000e-3 RG=1.0000000000e-4 RDS=1e9 CGS=8.9200000000e-10 CGDMAX=1.1900000000e-10 CGDMIN=1.1900000000e-10 CJO=2.3000000000e-11 IS=1.0000000000e-12 N=1.5000000000e0 RB=1.5200000000e-3)

.temp 25
M1 d1 g1 0 OC_HL_50N03
ID1 0 d1 DC 2.0000000000e1
VG1 g1 0 DC 1.0000000000e1
.op
.end
