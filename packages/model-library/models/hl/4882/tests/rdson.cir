OpenCircuit factory test: 4882 RDS(on)
* OpenCircuit Model Factory v0.1.0 bulk adapter
* Original work generated from public factual specifications.
* This model is not copied or adapted from any vendor SPICE model.
* Source: https://jlcpcb.com/api/file/downloadByFileSystemAccessId/8590908171483897856
* Revision: V2.0
.model OC_HL_4882 VDMOS( VTO=1.5000000000e0 KP=1.1764705882e2 THETA=0.0000000000e0 LAMBDA=3.0000000000e-3 RD=9.3500000000e-3 RS=3.4000000000e-3 RG=1.0000000000e-4 RDS=1e9 CGS=5.7500000000e-10 CGDMAX=5.8000000000e-11 CGDMIN=5.8000000000e-11 CJO=9.0000000000e-12 IS=1.0000000000e-12 N=1.5000000000e0 RB=3.4000000000e-3)

.temp 25
M1 d1 g1 0 OC_HL_4882
ID1 0 d1 DC 8.0000000000e0
VG1 g1 0 DC 1.0000000000e1
.op
.end
