* OpenCircuit Model Factory v0.1.0 bulk adapter
* Original work generated from public factual specifications.
* This model is not copied or adapted from any vendor SPICE model.
* Source: https://jlcpcb.com/api/file/downloadByFileSystemAccessId/8590903072380444672
* Revision: revision not stated in source
.model OC_NEXPERIA_PMEG10030ELPX D(IS=3.7264141982e-11 N=1.1000000000e0 RS=1.0000000000e-4)
