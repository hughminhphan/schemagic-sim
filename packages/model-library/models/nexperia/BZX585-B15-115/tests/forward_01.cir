OpenCircuit factory test: forward_01.cir
* OpenCircuit Model Factory v0.1.0 bulk adapter
* Original work generated from public factual specifications.
* This model is not copied or adapted from any vendor SPICE model.
* Source: https://jlcpcb.com/api/file/downloadByFileSystemAccessId/8590223655801425920
* Revision: revision not stated in source
.model OC_NEXPERIA_BZX585-B15-115 D(IS=3.5339464297e-11 N=1.8000000000e0 RS=1.0000000000e-4 BV=1.5000000000e1 IBV=5.0000000000e-3 NBV=1.0000000000e0)

.temp 2.5000000000e1
Itest 0 anode DC 1.0000000000e-2
Vanchor anchor 0 DC 0
Ranchor anchor 0 1G
Ddut anode 0 OC_NEXPERIA_BZX585-B15-115
.op
.end
