OpenCircuit factory test: BC846B Cobo
* OpenCircuit Model Factory v0.1.0
* Original work generated from public factual specifications.
* This model is not a copy of, or adaptation from, any vendor SPICE model.
* Source: https://assets.nexperia.com/documents/data-sheet/BC846_SER.pdf
* Revision: Rev. 9, 25 September 2012
* Fit: native ngspice-46 in scipy.optimize.least_squares, diff_step=1e-4
.model OC_NEXPERIA_BC846B NPN(IS=2.8203278568e-14 NF=1.0000000000e0 BF=1.1233179703e3 IKF=2.7699680690e-3 ISE=2.1230745165e-15 NE=1.2000560718e0 VAF=1.0000000000e2 BR=4.0000000000e0 RB=1.1650417828e1 RE=1.0000000000e-4 RC=6.3939384631e-4 CJE=1.3019753818e-11 VJE=7.5000000000e-1 MJE=3.3000000000e-1 CJC=7.2229703317e-12 VJC=7.5000000000e-1 MJC=3.3000000000e-1 XCJC=1.0000000000e0 TF=1.5395353111e-9 TR=0 FC=0.5 EG=1.11 XTI=3 TNOM=27)

.temp 25
VCB c 0 DC 10 AC 1
Q1 c b 0 OC_NEXPERIA_BC846B
VB b 0 DC 0
.ac lin 1 1Meg 1Meg
.end
