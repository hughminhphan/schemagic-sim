OpenCircuit factory test: BC817-40-QR DC gain
* OpenCircuit Model Factory v0.1.0 bulk adapter
* Original work generated from public factual specifications.
* This model is not copied or adapted from any vendor SPICE model.
* Source: https://jlcpcb.com/api/file/downloadByFileSystemAccessId/8590454675741966337
* Revision: Rev. 1 — 8 June 2021
.model OC_NEXPERIA_BC817-40-QR NPN(IS=1.0000000000e-14 BF=2.5250000000e2 VAF=1.0000000000e2 IKF=1.0000000000e3 RB=1.0000000000e1 RC=1.0000000000e-1 RE=5.0000000000e-2 CJE=1.0000000000e-12 CJC=1.0000000000e-12 TF=1.0000000000e-9)

.temp 25
VCG1 cg1 0 DC 1.0000000000e0
IBG1 0 bg1 DC 4.0000000000e-4
QG1 cg1 bg1 0 OC_NEXPERIA_BC817-40-QR
VCG2 cg2 0 DC 1.0000000000e0
IBG2 0 bg2 DC 1.2500000000e-2
QG2 cg2 bg2 0 OC_NEXPERIA_BC817-40-QR
.op
.end
