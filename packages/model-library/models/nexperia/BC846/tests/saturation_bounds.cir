OpenCircuit independent review: published BJT saturation hard bounds
* OpenCircuit Model Factory v0.1.0 bulk adapter
* Original work generated from public factual specifications.
* This model is not copied or adapted from any vendor SPICE model.
* Source: https://jlcpcb.com/api/file/downloadByFileSystemAccessId/8586189496299753472
* Revision: Rev. 12, 1 July 2022
.model OC_NEXPERIA_BC846-215 NPN(IS=1.0000000000e-14 BF=1.1000000000e2 VAF=1.0000000000e2 IKF=1.0000000000e3 RB=1.0000000000e1 RC=1.0000000000e-1 RE=5.0000000000e-2 CJE=1.0000000000e-12 CJC=1.0000000000e-12 TF=1.0000000000e-9)

.temp 25
IC2 0 c2 DC 0.01
IB2 0 b2 DC 0.0005
Q2 c2 b2 0 OC_NEXPERIA_BC846-215
IC4 0 c4 DC 0.1
IB4 0 b4 DC 0.005
Q4 c4 b4 0 OC_NEXPERIA_BC846-215
.op
.end
