OpenCircuit factory test: BC846-215 DC gain
* OpenCircuit Model Factory v0.1.0 bulk adapter
* Original work generated from public factual specifications.
* This model is not copied or adapted from any vendor SPICE model.
* Source: https://jlcpcb.com/api/file/downloadByFileSystemAccessId/8586189496299753472
* Revision: Rev. 12, 1 July 2022
.model OC_NEXPERIA_BC846-215 NPN(IS=1.0000000000e-14 BF=1.1000000000e2 VAF=1.0000000000e2 IKF=1.0000000000e3 RB=1.0000000000e1 RC=1.0000000000e-1 RE=5.0000000000e-2 CJE=1.0000000000e-12 CJC=1.0000000000e-12 TF=1.0000000000e-9)

.temp 25
VCG1 cg1 0 DC 5.0000000000e0
IBG1 0 bg1 DC 1.8181818182e-5
QG1 cg1 bg1 0 OC_NEXPERIA_BC846-215
.op
.end
