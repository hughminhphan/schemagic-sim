OpenCircuit factory test: BC807DS-115 output sanity
* OpenCircuit Model Factory v0.1.0 bulk adapter
* Original work generated from public factual specifications.
* This model is not copied or adapted from any vendor SPICE model.
* Source: https://jlcpcb.com/api/file/downloadByFileSystemAccessId/8588909697415434240
* Revision: v.4, 8 July 2024 (Product data sheet)
.model OC_NEXPERIA_BC807DS-115 PNP(IS=1.0000000000e-14 BF=2.7400000000e2 VAF=1.0000000000e2 IKF=1.0000000000e3 RB=1.0000000000e1 RC=1.0000000000e-1 RE=5.0000000000e-2 CJE=1.0000000000e-12 CJC=1.0000000000e-12 TF=1.0000000000e-9)

.temp 25
VCE1 c1 0 DC -2
IB1 0 b1 DC -0.00001
Q1 c1 b1 0 OC_NEXPERIA_BC807DS-115
VCE2 c2 0 DC -10
IB2 0 b2 DC -0.00005
Q2 c2 b2 0 OC_NEXPERIA_BC807DS-115
.op
.end
