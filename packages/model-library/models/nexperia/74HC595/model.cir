* OpenCircuit Model Factory v0.1.0
* Original work generated from public factual specifications.
* This model is not a copy of, or adaptation from, any vendor SPICE model.
* Source: https://assets.nexperia.com/documents/data-sheet/74HC_HCT595.pdf
* Revision: Rev. 12, 20 March 2024
* Archetype: archetype-logic74hc.md
* Fitted at 25 degC from the VCC = 4.5 V table column.
.subckt OC_NEXPERIA_74HC595_OUT IN Y VCC GND
BDRV yd GND V = min(max(v(IN)*v(VCC,GND),0),v(VCC,GND))
RDRV yd Y R={25.0+(30.0-25.0)*0.5*(1+tanh(12*(v(IN)-0.5)))}
.ends OC_NEXPERIA_74HC595_OUT
.subckt OC_NEXPERIA_74HC595_Z_OUT IN EN Y VCC GND
BDRV yd GND V = min(max(v(IN)*v(VCC,GND),0),v(VCC,GND))
RDRV yd Y R={(v(EN)>0.5) ? 1e9 : (25.0+(30.0-25.0)*0.5*(1+tanh(12*(v(IN)-0.5))))}
.ends OC_NEXPERIA_74HC595_Z_OUT
.subckt OC_NEXPERIA_74HC595_DFF D CLK Q QB SETN CLRN VCC GND
+ PARAMS: KIN=20 KREG=25 TAU=8.0000000000e-09 VSKEW=0.05
RID D GND 1e11
RIC CLK GND 1e11
RISET SETN GND 1e11
RICLR CLRN GND 1e11
BC c GND V = 0.5*(1+tanh(KIN*(v(CLK,GND)/v(VCC,GND)-0.5)))
BD dd GND V = 0.5*(1+tanh(KIN*(v(D,GND)/v(VCC,GND)-0.5)))
BSET st GND V = 0.5*(1+tanh(KIN*(v(SETN,GND)/v(VCC,GND)-0.5)))
BCLR cl GND V = 0.5*(1+tanh(KIN*(v(CLRN,GND)/v(VCC,GND)-0.5)))
BMA mad GND V = (v(cl)<0.5) ? ((v(st)<0.5) ? 1 : 0) : ((v(st)<0.5) ? 1 : ((v(c)<0.5) ? v(dd) : 0.5*(1-tanh(KREG*(v(mb)-0.5)))))
RMA mad ma {TAU/1p}
CMA ma GND 1p
BMB mbd GND V = (v(cl)<0.5) ? 1 : ((v(st)<0.5) ? ((v(cl)<0.5) ? 1 : 0) : 0.5*(1-tanh(KREG*(v(ma)-0.5))) + VSKEW)
RMB mbd mb {TAU/1p}
CMB mb GND 1p
BSA sad GND V = (v(cl)<0.5) ? ((v(st)<0.5) ? 1 : 0) : ((v(st)<0.5) ? 1 : ((v(c)>0.5) ? v(ma) : 0.5*(1-tanh(KREG*(v(sb)-0.5)))))
RSA sad sa {TAU/1p}
CSA sa GND 1p
BSB sbd GND V = (v(cl)<0.5) ? 1 : ((v(st)<0.5) ? ((v(cl)<0.5) ? 1 : 0) : 0.5*(1-tanh(KREG*(v(sa)-0.5))) + VSKEW)
RSB sbd sb {TAU/1p}
CSB sb GND 1p
XQ sa Q VCC GND OC_NEXPERIA_74HC595_OUT
XQB sb QB VCC GND OC_NEXPERIA_74HC595_OUT
.ends OC_NEXPERIA_74HC595_DFF
.subckt OC_NEXPERIA_74HC595 DS SHCP STCP MR OE Q0 Q1 Q2 Q3 Q4 Q5 Q6 Q7 Q7S VCC GND
RIoen OE GND 1e11
BIoen oen GND V = 0.5*(1+tanh(20*(v(OE,GND)/v(VCC,GND)-0.5)))
XS0 DS SHCP s0 sb0 VCC MR VCC GND OC_NEXPERIA_74HC595_DFF
XS1 s0 SHCP s1 sb1 VCC MR VCC GND OC_NEXPERIA_74HC595_DFF
XS2 s1 SHCP s2 sb2 VCC MR VCC GND OC_NEXPERIA_74HC595_DFF
XS3 s2 SHCP s3 sb3 VCC MR VCC GND OC_NEXPERIA_74HC595_DFF
XS4 s3 SHCP s4 sb4 VCC MR VCC GND OC_NEXPERIA_74HC595_DFF
XS5 s4 SHCP s5 sb5 VCC MR VCC GND OC_NEXPERIA_74HC595_DFF
XS6 s5 SHCP s6 sb6 VCC MR VCC GND OC_NEXPERIA_74HC595_DFF
XS7 s6 SHCP s7 sb7 VCC MR VCC GND OC_NEXPERIA_74HC595_DFF
XL0 s0 STCP l0 lb0 VCC VCC VCC GND OC_NEXPERIA_74HC595_DFF
BLO0 lo0 GND V = v(l0)/v(VCC,GND)
XO0 lo0 oen Q0 VCC GND OC_NEXPERIA_74HC595_Z_OUT
XL1 s1 STCP l1 lb1 VCC VCC VCC GND OC_NEXPERIA_74HC595_DFF
BLO1 lo1 GND V = v(l1)/v(VCC,GND)
XO1 lo1 oen Q1 VCC GND OC_NEXPERIA_74HC595_Z_OUT
XL2 s2 STCP l2 lb2 VCC VCC VCC GND OC_NEXPERIA_74HC595_DFF
BLO2 lo2 GND V = v(l2)/v(VCC,GND)
XO2 lo2 oen Q2 VCC GND OC_NEXPERIA_74HC595_Z_OUT
XL3 s3 STCP l3 lb3 VCC VCC VCC GND OC_NEXPERIA_74HC595_DFF
BLO3 lo3 GND V = v(l3)/v(VCC,GND)
XO3 lo3 oen Q3 VCC GND OC_NEXPERIA_74HC595_Z_OUT
XL4 s4 STCP l4 lb4 VCC VCC VCC GND OC_NEXPERIA_74HC595_DFF
BLO4 lo4 GND V = v(l4)/v(VCC,GND)
XO4 lo4 oen Q4 VCC GND OC_NEXPERIA_74HC595_Z_OUT
XL5 s5 STCP l5 lb5 VCC VCC VCC GND OC_NEXPERIA_74HC595_DFF
BLO5 lo5 GND V = v(l5)/v(VCC,GND)
XO5 lo5 oen Q5 VCC GND OC_NEXPERIA_74HC595_Z_OUT
XL6 s6 STCP l6 lb6 VCC VCC VCC GND OC_NEXPERIA_74HC595_DFF
BLO6 lo6 GND V = v(l6)/v(VCC,GND)
XO6 lo6 oen Q6 VCC GND OC_NEXPERIA_74HC595_Z_OUT
XL7 s7 STCP l7 lb7 VCC VCC VCC GND OC_NEXPERIA_74HC595_DFF
BLO7 lo7 GND V = v(l7)/v(VCC,GND)
XO7 lo7 oen Q7 VCC GND OC_NEXPERIA_74HC595_Z_OUT
BSO son GND V = v(s7)/v(VCC,GND)
XSO son Q7S VCC GND OC_NEXPERIA_74HC595_OUT
.ends OC_NEXPERIA_74HC595
