OpenCircuit factory test: PMBT3904-215 DC gain
* OpenCircuit Model Factory v0.1.0 bulk adapter
* Original work generated from public factual specifications.
* This model is not copied or adapted from any vendor SPICE model.
* Source: https://jlcpcb.com/api/file/downloadByFileSystemAccessId/8586172647176876033
* Revision: PMBT3904 v.5 (20240216)
.model OC_NEXPERIA_PMBT3904-215 NPN(IS=1.0000000000e-14 BF=2.0830583320e2 VAF=1.0000000000e2 IKF=1.0000000000e3 RB=1.0000000000e1 RC=1.0000000000e-1 RE=5.0000000000e-2 CJE=1.0000000000e-12 CJC=1.0000000000e-12 TF=1.0000000000e-9)

.temp 25
VCG1 cg1 0 DC 1.0000000000e0
IBG1 0 bg1 DC 1.6666666667e-6
QG1 cg1 bg1 0 OC_NEXPERIA_PMBT3904-215
VCG2 cg2 0 DC 1.0000000000e0
IBG2 0 bg2 DC 1.2500000000e-5
QG2 cg2 bg2 0 OC_NEXPERIA_PMBT3904-215
VCG3 cg3 0 DC 1.0000000000e0
IBG3 0 bg3 DC 1.0000000000e-4
QG3 cg3 bg3 0 OC_NEXPERIA_PMBT3904-215
VCG4 cg4 0 DC 1.0000000000e0
IBG4 0 bg4 DC 8.3333333333e-4
QG4 cg4 bg4 0 OC_NEXPERIA_PMBT3904-215
VCG5 cg5 0 DC 1.0000000000e0
IBG5 0 bg5 DC 3.3333333333e-3
QG5 cg5 bg5 0 OC_NEXPERIA_PMBT3904-215
VCG6 cg6 0 DC 1.0000000000e0
IBG6 0 bg6 DC 4.8563440085e-6
QG6 cg6 bg6 0 OC_NEXPERIA_PMBT3904-215
.op
.end
