OpenCircuit factory test: PMBT3904-215 supported-region upper-current boundary
* OpenCircuit Model Factory v0.1.0 bulk adapter
* Original work generated from public factual specifications.
* This model is not copied or adapted from any vendor SPICE model.
* Source: https://jlcpcb.com/api/file/downloadByFileSystemAccessId/8586172647176876033
* Revision: PMBT3904 v.5 (20240216)
.model OC_NEXPERIA_PMBT3904-215 NPN(IS=1.0000000000e-14 BF=2.0830583320e2 VAF=1.0000000000e2 IKF=1.0000000000e3 RB=1.0000000000e1 RC=1.0000000000e-1 RE=5.0000000000e-2 CJE=1.0000000000e-12 CJC=1.0000000000e-12 TF=1.0000000000e-9)

.temp 25
IC 0 c DC 1.0000000000e-1
IB 0 b DC 3.3333333333e-3
Q1 c b 0 OC_NEXPERIA_PMBT3904-215
.op
.end
