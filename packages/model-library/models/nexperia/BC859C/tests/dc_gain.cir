OpenCircuit factory test: BC859C-215 DC gain
* OpenCircuit Model Factory v0.1.0 bulk adapter
* Original work generated from public factual specifications.
* This model is not copied or adapted from any vendor SPICE model.
* Source: https://jlcpcb.com/api/file/downloadByFileSystemAccessId/8588911541232013312
* Revision: 2004 Jan 16
.model OC_NEXPERIA_BC859C-215 PNP(IS=1.0000000000e-14 BF=4.2420000000e2 VAF=1.0000000000e2 IKF=1.0000000000e3 RB=1.0000000000e1 RC=1.0000000000e-1 RE=5.0000000000e-2 CJE=1.0000000000e-12 CJC=1.0000000000e-12 TF=1.0000000000e-9)

.temp 25
VCG1 cg1 0 DC -5.0000000000e0
IBG1 0 bg1 DC -4.7619047619e-6
QG1 cg1 bg1 0 OC_NEXPERIA_BC859C-215
.op
.end
