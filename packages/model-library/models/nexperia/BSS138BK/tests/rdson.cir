OpenCircuit factory test: BSS138BK-215 RDS(on)
* OpenCircuit Model Factory v0.1.0 bulk adapter
* Original work generated from public factual specifications.
* This model is not copied or adapted from any vendor SPICE model.
* Source: https://jlcpcb.com/api/file/downloadByFileSystemAccessId/8588884658218283008
* Revision: Rev. 1 - 4 August 2011 (Product data sheet, Nexperia 2017 imprint)
.model OC_NEXPERIA_BSS138BK-215 VDMOS( VTO=1.1000000000e0 KP=2.0000000000e0 THETA=0.0000000000e0 LAMBDA=3.0000000000e-3 RD=5.5000000000e-1 RS=2.0000000000e-1 RG=1.0000000000e-4 RDS=1e9 CGS=3.8000000000e-11 CGDMAX=4.0000000000e-12 CGDMIN=4.0000000000e-12 CJO=3.0000000000e-12 IS=1.0000000000e-12 N=1.5000000000e0 RB=2.0000000000e-1)

.temp 25
M1 d1 g1 0 OC_NEXPERIA_BSS138BK-215
ID1 0 d1 DC 3.5000000000e-1
VG1 g1 0 DC 1.0000000000e1
.op
.end
