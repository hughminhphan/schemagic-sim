* OpenCircuit Model Factory v0.1.0 bulk adapter
* Original work generated from public factual specifications.
* This model is not copied or adapted from any vendor SPICE model.
* Source: https://jlcpcb.com/api/file/downloadByFileSystemAccessId/8586175000180744192
* Revision: BAS321 v4, 1 July 2022
.model OC_NEXPERIA_BAS321-115 D(IS=4.1818003378e-15 N=1.1037982665e0 RS=8.0838061825e-1)
