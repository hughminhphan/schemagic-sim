OpenCircuit independent review hard-bound probe
* OpenCircuit Model Factory v0.1.0 bulk adapter
* Original work generated from public factual specifications.
* This model is not copied or adapted from any vendor SPICE model.
* Source: https://jlcpcb.com/api/file/downloadByFileSystemAccessId/8586199742661464064
* Revision: NX7002AK v.7 - 6 August 2015
.model OC_NEXPERIA_NX7002AK-215 VDMOS( VTO=1.6000000000e0 KP=6.6666666667e-1 THETA=0.0000000000e0 LAMBDA=3.0000000000e-3 RD=1.6500000000e0 RS=6.0000000000e-1 RG=1.0000000000e-4 RDS=1e9 CGS=1.3000000000e-11 CGDMAX=2.0000000000e-12 CGDMIN=2.0000000000e-12 CJO=1.4000000000e-12 IS=1.0000000000e-12 N=1.5000000000e0 RB=6.0000000000e-1)
.temp 25
M1 d g 0 OC_NEXPERIA_NX7002AK-215
ID 0 d DC 0.1
VG g 0 DC 5.0
.op
.end
