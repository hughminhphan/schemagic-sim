* OpenCircuit Model Factory v0.1.0 bulk adapter
* Original work generated from public factual specifications.
* This model is not copied or adapted from any vendor SPICE model.
* Source: https://jlcpcb.com/api/file/downloadByFileSystemAccessId/8586177223473053696
* Revision: v.6
.model OC_NEXPERIA_BAT54C-215 D(IS=2.1612589492e-5 N=1.1000000000e0 RS=1.0000000000e-4)
