* BZX79C5V1 zener boundary at 0.005 A
* OpenCircuit Model Factory v0.1.0
* Original work generated from public factual specifications.
* This model is not a copy of, or adaptation from, any vendor SPICE model.
* Source: https://assets.nexperia.com/documents/data-sheet/BZX79.pdf
* Revision: M3D176, 2002 Feb 27
* Archetype: archetype-diode.md, variant Z; fit reference 25 degC
* Node order: D1 anode cathode OC_NEXPERIA_BZX79C5V1
.model OC_NEXPERIA_BZX79C5V1 D(IS=1e-14 N=1.6 RS=1.0000000000e-04 BV=5.1000000000e+00 IBV=5.0000000000e-03 NBV=1.0000000000e+00)
.temp 25
IZ 0 cathode DC 0.005
Vanchor anchor 0 DC 0
Ranchor anchor 0 1G
D1 0 cathode OC_NEXPERIA_BZX79C5V1
.op
.end
