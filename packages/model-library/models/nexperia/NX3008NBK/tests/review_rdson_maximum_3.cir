OpenCircuit independent review hard-bound probe
* OpenCircuit Model Factory v0.1.0 bulk adapter
* Original work generated from public factual specifications.
* This model is not copied or adapted from any vendor SPICE model.
* Source: https://jlcpcb.com/api/file/downloadByFileSystemAccessId/8586187818058600448
* Revision: NX3008NBK v.2, released 5 November 2022
.model OC_NEXPERIA_NX3008NBK-215 VDMOS( VTO=9.0000000000e-1 KP=2.0000000000e0 THETA=0.0000000000e0 LAMBDA=3.0000000000e-3 RD=5.5000000000e-1 RS=2.0000000000e-1 RG=1.0000000000e-4 RDS=1e9 CGS=3.1800000000e-11 CGDMAX=2.2000000000e-12 CGDMIN=2.2000000000e-12 CJO=4.3000000000e-12 IS=1.0000000000e-12 N=1.5000000000e0 RB=2.0000000000e-1)
.temp 25
M1 d g 0 OC_NEXPERIA_NX3008NBK-215
ID 0 d DC 1.000000000000e-2
VG g 0 DC 1.800000000000e+0
.op
.end
