74HC165 minimum supply boundary
* OpenCircuit Model Factory v0.1.0
* Original work generated from public factual specifications.
* This model is not a copy of, or adaptation from, any vendor SPICE model.
* Source: https://assets.nexperia.com/documents/data-sheet/74HC_HCT165.pdf
* Revision: Rev. 8, 9 May 2025
* Archetype: archetype-logic74hc.md
* Fitted at 25 degC from the VCC = 4.5 V table column.
.subckt OC_NEXPERIA_74HC165_OUT IN Y VCC GND
BDRV yd GND V = min(max(v(IN)*v(VCC,GND),0),v(VCC,GND))
RDRV yd Y R={37.5+(45.0-37.5)*0.5*(1+tanh(12*(v(IN)-0.5)))}
.ends OC_NEXPERIA_74HC165_OUT
.subckt OC_NEXPERIA_74HC165_DFF D CLK Q QB SETN CLRN VCC GND
+ PARAMS: KIN=20 KREG=25 TAU=8.5000000000e-09 VSKEW=0.05
RID D GND 1e11
RIC CLK GND 1e11
RISET SETN GND 1e11
RICLR CLRN GND 1e11
BC c GND V = 0.5*(1+tanh(KIN*(v(CLK,GND)/v(VCC,GND)-0.5)))
BD dd GND V = 0.5*(1+tanh(KIN*(v(D,GND)/v(VCC,GND)-0.5)))
BSET st GND V = 0.5*(1+tanh(KIN*(v(SETN,GND)/v(VCC,GND)-0.5)))
BCLR cl GND V = 0.5*(1+tanh(KIN*(v(CLRN,GND)/v(VCC,GND)-0.5)))
BMA mad GND V = (v(cl)<0.5) ? ((v(st)<0.5) ? 1 : 0) : ((v(st)<0.5) ? 1 : ((v(c)<0.5) ? v(dd) : 0.5*(1-tanh(KREG*(v(mb)-0.5)))))
RMA mad ma {TAU/1p}
CMA ma GND 1p
BMB mbd GND V = (v(cl)<0.5) ? 1 : ((v(st)<0.5) ? ((v(cl)<0.5) ? 1 : 0) : 0.5*(1-tanh(KREG*(v(ma)-0.5))) + VSKEW)
RMB mbd mb {TAU/1p}
CMB mb GND 1p
BSA sad GND V = (v(cl)<0.5) ? ((v(st)<0.5) ? 1 : 0) : ((v(st)<0.5) ? 1 : ((v(c)>0.5) ? v(ma) : 0.5*(1-tanh(KREG*(v(sb)-0.5)))))
RSA sad sa {TAU/1p}
CSA sa GND 1p
BSB sbd GND V = (v(cl)<0.5) ? 1 : ((v(st)<0.5) ? ((v(cl)<0.5) ? 1 : 0) : 0.5*(1-tanh(KREG*(v(sa)-0.5))) + VSKEW)
RSB sbd sb {TAU/1p}
CSB sb GND 1p
XQ sa Q VCC GND OC_NEXPERIA_74HC165_OUT
XQB sb QB VCC GND OC_NEXPERIA_74HC165_OUT
.ends OC_NEXPERIA_74HC165_DFF
.subckt OC_NEXPERIA_74HC165 PL CP CE DS D0 D1 D2 D3 D4 D5 D6 D7 Q7 Q7B VCC GND
RIpln PL GND 1e11
BIpln pln GND V = 0.5*(1+tanh(20*(v(PL,GND)/v(VCC,GND)-0.5)))
RIcpn CP GND 1e11
BIcpn cpn GND V = 0.5*(1+tanh(20*(v(CP,GND)/v(VCC,GND)-0.5)))
RIcen CE GND 1e11
BIcen cen GND V = 0.5*(1+tanh(20*(v(CE,GND)/v(VCC,GND)-0.5)))
RIdsn DS GND 1e11
BIdsn dsn GND V = 0.5*(1+tanh(20*(v(DS,GND)/v(VCC,GND)-0.5)))
RId0n D0 GND 1e11
BId0n d0n GND V = 0.5*(1+tanh(20*(v(D0,GND)/v(VCC,GND)-0.5)))
RId1n D1 GND 1e11
BId1n d1n GND V = 0.5*(1+tanh(20*(v(D1,GND)/v(VCC,GND)-0.5)))
RId2n D2 GND 1e11
BId2n d2n GND V = 0.5*(1+tanh(20*(v(D2,GND)/v(VCC,GND)-0.5)))
RId3n D3 GND 1e11
BId3n d3n GND V = 0.5*(1+tanh(20*(v(D3,GND)/v(VCC,GND)-0.5)))
RId4n D4 GND 1e11
BId4n d4n GND V = 0.5*(1+tanh(20*(v(D4,GND)/v(VCC,GND)-0.5)))
RId5n D5 GND 1e11
BId5n d5n GND V = 0.5*(1+tanh(20*(v(D5,GND)/v(VCC,GND)-0.5)))
RId6n D6 GND 1e11
BId6n d6n GND V = 0.5*(1+tanh(20*(v(D6,GND)/v(VCC,GND)-0.5)))
RId7n D7 GND 1e11
BId7n d7n GND V = 0.5*(1+tanh(20*(v(D7,GND)/v(VCC,GND)-0.5)))
BCLK clkx GND V = v(VCC,GND)*v(cpn)*(1-v(cen))
BDS dsx GND V = v(VCC,GND)*v(dsn)
BSET0 set0 GND V = v(VCC,GND)*min(max(v(pln)+(1-v(d0n)),0),1)
BCLR0 clr0 GND V = v(VCC,GND)*min(max(v(pln)+v(d0n),0),1)
XFF0 dsx clkx s0 sb0 set0 clr0 VCC GND OC_NEXPERIA_74HC165_DFF
BSET1 set1 GND V = v(VCC,GND)*min(max(v(pln)+(1-v(d1n)),0),1)
BCLR1 clr1 GND V = v(VCC,GND)*min(max(v(pln)+v(d1n),0),1)
XFF1 s0 clkx s1 sb1 set1 clr1 VCC GND OC_NEXPERIA_74HC165_DFF
BSET2 set2 GND V = v(VCC,GND)*min(max(v(pln)+(1-v(d2n)),0),1)
BCLR2 clr2 GND V = v(VCC,GND)*min(max(v(pln)+v(d2n),0),1)
XFF2 s1 clkx s2 sb2 set2 clr2 VCC GND OC_NEXPERIA_74HC165_DFF
BSET3 set3 GND V = v(VCC,GND)*min(max(v(pln)+(1-v(d3n)),0),1)
BCLR3 clr3 GND V = v(VCC,GND)*min(max(v(pln)+v(d3n),0),1)
XFF3 s2 clkx s3 sb3 set3 clr3 VCC GND OC_NEXPERIA_74HC165_DFF
BSET4 set4 GND V = v(VCC,GND)*min(max(v(pln)+(1-v(d4n)),0),1)
BCLR4 clr4 GND V = v(VCC,GND)*min(max(v(pln)+v(d4n),0),1)
XFF4 s3 clkx s4 sb4 set4 clr4 VCC GND OC_NEXPERIA_74HC165_DFF
BSET5 set5 GND V = v(VCC,GND)*min(max(v(pln)+(1-v(d5n)),0),1)
BCLR5 clr5 GND V = v(VCC,GND)*min(max(v(pln)+v(d5n),0),1)
XFF5 s4 clkx s5 sb5 set5 clr5 VCC GND OC_NEXPERIA_74HC165_DFF
BSET6 set6 GND V = v(VCC,GND)*min(max(v(pln)+(1-v(d6n)),0),1)
BCLR6 clr6 GND V = v(VCC,GND)*min(max(v(pln)+v(d6n),0),1)
XFF6 s5 clkx s6 sb6 set6 clr6 VCC GND OC_NEXPERIA_74HC165_DFF
BSET7 set7 GND V = v(VCC,GND)*min(max(v(pln)+(1-v(d7n)),0),1)
BCLR7 clr7 GND V = v(VCC,GND)*min(max(v(pln)+v(d7n),0),1)
XFF7 s6 clkx s7 sb7 set7 clr7 VCC GND OC_NEXPERIA_74HC165_DFF
B7 q7n GND V = v(s7)/v(VCC,GND)
B7B q7bn GND V = v(sb7)/v(VCC,GND)
XQ7 q7n Q7 VCC GND OC_NEXPERIA_74HC165_OUT
XQ7B q7bn Q7B VCC GND OC_NEXPERIA_74HC165_OUT
.ends OC_NEXPERIA_74HC165
.temp 25
VCC vcc 0 2
VPL pl 0 PWL(0 2 0.1u 2 0.11u 0 0.5u 0 0.51u 2)
VCP cp 0 0
VCE ce 0 0
VDS ds 0 0
VD0 d0 0 0
VD1 d1 0 0
VD2 d2 0 0
VD3 d3 0 0
VD4 d4 0 0
VD5 d5 0 0
VD6 d6 0 0
VD7 d7 0 2
X1 pl cp ce ds d0 d1 d2 d3 d4 d5 d6 d7 q7 q7b vcc 0 OC_NEXPERIA_74HC165
.tran 1n 1u
.measure tran q7_loaded FIND v(q7) AT=0.8u
.end
