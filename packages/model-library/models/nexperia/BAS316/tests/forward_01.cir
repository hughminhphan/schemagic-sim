OpenCircuit factory test: forward_01.cir
* OpenCircuit Model Factory v0.1.0 bulk adapter
* Original work generated from public factual specifications.
* This model is not copied or adapted from any vendor SPICE model.
* Source: https://jlcpcb.com/api/file/downloadByFileSystemAccessId/8588898867752001536
* Revision: BAS316 v7, 1 July 2022
.model OC_NEXPERIA_BAS316-115 D(IS=6.4687160222e-9 N=1.9939588699e0 RS=9.4740581715e-1)

.temp 25
Itest 0 anode DC 1.0000000000e-4
Vanchor anchor 0 DC 0
Ranchor anchor 0 1G
Ddut anode 0 OC_NEXPERIA_BAS316-115
.op
.end
