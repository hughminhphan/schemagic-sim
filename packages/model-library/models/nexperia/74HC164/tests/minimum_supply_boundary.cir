74HC164 minimum supply boundary
* OpenCircuit Model Factory v0.1.0
* Original work generated from public factual specifications.
* This model is not a copy of, or adaptation from, any vendor SPICE model.
* Source: https://assets.nexperia.com/documents/data-sheet/74HC_HCT164.pdf
* Revision: Rev. 11, 28 May 2024
* Archetype: archetype-logic74hc.md
* Fitted at 25 degC from the VCC = 4.5 V table column.
.subckt OC_NEXPERIA_74HC164_OUT IN Y VCC GND
BDRV yd GND V = min(max(v(IN)*v(VCC,GND),0),v(VCC,GND))
RDRV yd Y R={37.5+(45.0-37.5)*0.5*(1+tanh(12*(v(IN)-0.5)))}
.ends OC_NEXPERIA_74HC164_OUT
.subckt OC_NEXPERIA_74HC164_DFF D CLK Q QB SETN CLRN VCC GND
+ PARAMS: KIN=20 KREG=25 TAU=6.5000000000e-09 VSKEW=0.05
RID D GND 1e11
RIC CLK GND 1e11
RISET SETN GND 1e11
RICLR CLRN GND 1e11
BC c GND V = 0.5*(1+tanh(KIN*(v(CLK,GND)/v(VCC,GND)-0.5)))
BD dd GND V = 0.5*(1+tanh(KIN*(v(D,GND)/v(VCC,GND)-0.5)))
BSET st GND V = 0.5*(1+tanh(KIN*(v(SETN,GND)/v(VCC,GND)-0.5)))
BCLR cl GND V = 0.5*(1+tanh(KIN*(v(CLRN,GND)/v(VCC,GND)-0.5)))
BMA mad GND V = (v(cl)<0.5) ? ((v(st)<0.5) ? 1 : 0) : ((v(st)<0.5) ? 1 : ((v(c)<0.5) ? v(dd) : 0.5*(1-tanh(KREG*(v(mb)-0.5)))))
RMA mad ma {TAU/1p}
CMA ma GND 1p
BMB mbd GND V = (v(cl)<0.5) ? 1 : ((v(st)<0.5) ? ((v(cl)<0.5) ? 1 : 0) : 0.5*(1-tanh(KREG*(v(ma)-0.5))) + VSKEW)
RMB mbd mb {TAU/1p}
CMB mb GND 1p
BSA sad GND V = (v(cl)<0.5) ? ((v(st)<0.5) ? 1 : 0) : ((v(st)<0.5) ? 1 : ((v(c)>0.5) ? v(ma) : 0.5*(1-tanh(KREG*(v(sb)-0.5)))))
RSA sad sa {TAU/1p}
CSA sa GND 1p
BSB sbd GND V = (v(cl)<0.5) ? 1 : ((v(st)<0.5) ? ((v(cl)<0.5) ? 1 : 0) : 0.5*(1-tanh(KREG*(v(sa)-0.5))) + VSKEW)
RSB sbd sb {TAU/1p}
CSB sb GND 1p
XQ sa Q VCC GND OC_NEXPERIA_74HC164_OUT
XQB sb QB VCC GND OC_NEXPERIA_74HC164_OUT
.ends OC_NEXPERIA_74HC164_DFF
.subckt OC_NEXPERIA_74HC164 DSA DSB Q0 Q1 Q2 Q3 Q4 Q5 Q6 Q7 CP MR VCC GND
RIda DSA GND 1e11
BIda da GND V = 0.5*(1+tanh(20*(v(DSA,GND)/v(VCC,GND)-0.5)))
RIdb DSB GND 1e11
BIdb db GND V = 0.5*(1+tanh(20*(v(DSB,GND)/v(VCC,GND)-0.5)))
BDIN din GND V = v(VCC,GND)*v(da)*v(db)
XFF0 din CP Q0 qb0 VCC MR VCC GND OC_NEXPERIA_74HC164_DFF
XFF1 Q0 CP Q1 qb1 VCC MR VCC GND OC_NEXPERIA_74HC164_DFF
XFF2 Q1 CP Q2 qb2 VCC MR VCC GND OC_NEXPERIA_74HC164_DFF
XFF3 Q2 CP Q3 qb3 VCC MR VCC GND OC_NEXPERIA_74HC164_DFF
XFF4 Q3 CP Q4 qb4 VCC MR VCC GND OC_NEXPERIA_74HC164_DFF
XFF5 Q4 CP Q5 qb5 VCC MR VCC GND OC_NEXPERIA_74HC164_DFF
XFF6 Q5 CP Q6 qb6 VCC MR VCC GND OC_NEXPERIA_74HC164_DFF
XFF7 Q6 CP Q7 qb7 VCC MR VCC GND OC_NEXPERIA_74HC164_DFF
.ends OC_NEXPERIA_74HC164
.temp 25
VCC vcc 0 2
VMR mr 0 PWL(0 0 0.1u 0 0.11u 2)
VA a 0 2
VB b 0 2
VCP cp 0 PULSE(0 2 0.5u 3n 3n 0.3u 1u)
X1 a b q0 q1 q2 q3 q4 q5 q6 q7 cp mr vcc 0 OC_NEXPERIA_74HC164
.tran 1n 1.5u
.measure tran q0_final FIND v(q0) AT=1.4u
.end
