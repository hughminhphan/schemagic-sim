* OpenCircuit Model Factory v0.1.0
* Original work generated from public factual specifications.
* This model is not a copy of, or adaptation from, any vendor SPICE model.
* Source: https://assets.nexperia.com/documents/data-sheet/74HC_HCT00.pdf
* Revision: Rev. 11, 29 April 2025
* Archetype: archetype-logic74hc.md
* Fit run: H1-74hc-74HC00-2026-08-07
* Node order: A B Y VCC GND
.subckt OC_NEXPERIA_74HC00_GATE A B Y VCC GND
+ PARAMS: KVTC=9.4691729936 RINT=1k CINT=9.14811470501e-12 ROH=45 ROL=37.5 KSW=12
RIA A GND 1e11
RIB B GND 1e11
BAA aa GND V = 0.5*(1+tanh(KVTC*(v(A,GND)/v(VCC,GND)-0.5)))
BBB bb GND V = 0.5*(1+tanh(KVTC*(v(B,GND)/v(VCC,GND)-0.5)))
BVTC vi GND V = v(VCC,GND)*(1-v(aa)*v(bb))
RD vi vd {RINT}
CD vd GND {CINT}
BDRV yd GND V = min(max(v(vd),0),v(VCC,GND))
RDRV yd Y R={ROL+(ROH-ROL)*0.5*(1+tanh(KSW*(v(vd)/v(VCC,GND)-0.5)))}
.ends OC_NEXPERIA_74HC00_GATE
