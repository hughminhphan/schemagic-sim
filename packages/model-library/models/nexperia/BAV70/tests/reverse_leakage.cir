OpenCircuit factory test: reverse leakage
* OpenCircuit Model Factory v0.1.0 bulk adapter
* Original work generated from public factual specifications.
* This model is not copied or adapted from any vendor SPICE model.
* Source: https://jlcpcb.com/api/file/downloadByFileSystemAccessId/8579710807724523520
* Revision: BAV70 v0.9, 1 July 2022
.model OC_NEXPERIA_BAV70-215 D(IS=2.3911894576e-8 N=2.2773432469e0 RS=7.7313517482e-1)

.temp 25
Vreverse cathode 0 DC 8.0000000000e1
Ddut 0 cathode OC_NEXPERIA_BAV70-215
.op
.end
