* OpenCircuit Model Factory v0.1.0 bulk adapter
* Original work generated from public factual specifications.
* This model is not copied or adapted from any vendor SPICE model.
* Source: https://jlcpcb.com/api/file/downloadByFileSystemAccessId/8588915600903049216
* Revision: Rev. 4 — 1 January 2023
.model OC_NEXPERIA_BZX384-B24-115 D(IS=6.0191557579e-11 N=1.8000000000e0 RS=1.0000000000e-4 BV=2.3500000000e1 IBV=5.0000000000e-3 NBV=1.0000000000e0)
