* OpenCircuit Model Factory v0.1.0 bulk adapter
* Original work generated from public factual specifications.
* This model is not copied or adapted from any vendor SPICE model.
* Source: https://jlcpcb.com/api/file/downloadByFileSystemAccessId/8588909468444184576
* Revision: revision not stated in source
.model OC_NEXPERIA_PMEG4010CEH-115 D(IS=2.9634410524e-8 N=1.1000000000e0 RS=1.0000000000e-4)
