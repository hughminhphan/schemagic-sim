OpenCircuit factory test: PMBT4403-215 DC gain
* OpenCircuit Model Factory v0.1.0 bulk adapter
* Original work generated from public factual specifications.
* This model is not copied or adapted from any vendor SPICE model.
* Source: https://jlcpcb.com/api/file/downloadByFileSystemAccessId/8586180188208582656
* Revision: PMBT4403 v.5,5 March 2015
.model OC_NEXPERIA_PMBT4403-215 PNP(IS=1.0000000000e-14 BF=3.0000000000e2 VAF=1.0000000000e2 IKF=1.0000000000e3 RB=1.0000000000e1 RC=1.0000000000e-1 RE=5.0000000000e-2 CJE=1.0000000000e-12 CJC=1.0000000000e-12 TF=1.0000000000e-9)

.temp 25
VCG1 cg1 0 DC -1.0000000000e0
IBG1 0 bg1 DC -3.3333333333e-6
QG1 cg1 bg1 0 OC_NEXPERIA_PMBT4403-215
VCG2 cg2 0 DC -1.0000000000e0
IBG2 0 bg2 DC -1.6666666667e-5
QG2 cg2 bg2 0 OC_NEXPERIA_PMBT4403-215
VCG3 cg3 0 DC -1.0000000000e0
IBG3 0 bg3 DC -1.0000000000e-4
QG3 cg3 bg3 0 OC_NEXPERIA_PMBT4403-215
VCG4 cg4 0 DC -2.0000000000e0
IBG4 0 bg4 DC -1.5000000000e-3
QG4 cg4 bg4 0 OC_NEXPERIA_PMBT4403-215
VCG5 cg5 0 DC -2.0000000000e0
IBG5 0 bg5 DC -2.5000000000e-2
QG5 cg5 bg5 0 OC_NEXPERIA_PMBT4403-215
VCG6 cg6 0 DC -2.0000000000e0
IBG6 0 bg6 DC -3.4482758621e-7
QG6 cg6 bg6 0 OC_NEXPERIA_PMBT4403-215
.op
.end
