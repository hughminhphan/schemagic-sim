OpenCircuit independent review hard-bound probe
* OpenCircuit Model Factory v0.1.0 bulk adapter
* Original work generated from public factual specifications.
* This model is not copied or adapted from any vendor SPICE model.
* Source: https://jlcpcb.com/api/file/downloadByFileSystemAccessId/8588884796995489792
* Revision: Rev. 1 - 2 November 2010
.model OC_NEXPERIA_BSS138PS-115 VDMOS( VTO=1.3674804219e0 KP=1.5133408015e0 THETA=3.1058276564e-1 LAMBDA=3.9338916695e-2 RD=4.4157012970e-1 RS=2.0000000000e-1 RG=1.0000000000e-4 RDS=1e9 CGS=3.4000000000e-11 CGDMAX=4.0000000000e-12 CGDMIN=4.0000000000e-12 CJO=3.0000000000e-12 IS=1.0000000000e-12 N=1.5000000000e0 RB=2.0000000000e-1)
.temp 25
M1 d g 0 OC_NEXPERIA_BSS138PS-115
ID 0 d DC 0.05
VG g 0 DC 5.0
.op
.end
