* OpenCircuit Model Factory v0.1.0 bulk adapter
* Original work generated from public factual specifications.
* This model is not copied or adapted from any vendor SPICE model.
* Source: https://jlcpcb.com/api/file/downloadByFileSystemAccessId/8588914380323377152
* Revision: revision not stated in source
.model OC_NEXPERIA_BZX84J-C30-115 D(IS=9.0739070611e-12 N=1.8000000000e0 RS=1.0000000000e-4)
