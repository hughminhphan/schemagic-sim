* OpenCircuit Model Factory v0.1.0 bulk adapter
* Original work generated from public factual specifications.
* This model is not copied or adapted from any vendor SPICE model.
* Source: https://jlcpcb.com/api/file/downloadByFileSystemAccessId/8586186000074739712
* Revision: datasheet as supplied
.model OC_NEXPERIA_BAT46WJ-115 D(IS=3.0752753359e-12 N=1.1000000000e0 RS=1.0000000000e-4)
