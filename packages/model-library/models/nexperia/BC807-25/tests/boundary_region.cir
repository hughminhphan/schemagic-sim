OpenCircuit factory test: BC807-25-215 supported-region upper-current boundary
* OpenCircuit Model Factory v0.1.0 bulk adapter
* Original work generated from public factual specifications.
* This model is not copied or adapted from any vendor SPICE model.
* Source: https://jlcpcb.com/api/file/downloadByFileSystemAccessId/8586179348705107968
* Revision: Rev. 8 — 1 July 2022
.model OC_NEXPERIA_BC807-25-215 PNP(IS=1.0000000000e-14 BF=1.6160000000e2 VAF=1.0000000000e2 IKF=1.0000000000e3 RB=1.0000000000e1 RC=1.0000000000e-1 RE=5.0000000000e-2 CJE=1.0000000000e-12 CJC=1.0000000000e-12 TF=1.0000000000e-9)

.temp 25
IC 0 c DC -5.0000000000e-1
IB 0 b DC -1.2500000000e-2
Q1 c b 0 OC_NEXPERIA_BC807-25-215
.op
.end
