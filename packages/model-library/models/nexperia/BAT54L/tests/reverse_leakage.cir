OpenCircuit factory test: reverse leakage
* OpenCircuit Model Factory v0.1.0 bulk adapter
* Original work generated from public factual specifications.
* This model is not copied or adapted from any vendor SPICE model.
* Source: https://jlcpcb.com/api/file/downloadByFileSystemAccessId/8588912994449838080
* Revision: BAT54L v.2, 3 September 2018
.model OC_NEXPERIA_BAT54L-315 D(IS=4.3562909035e-7 N=1.0682508537e0 RS=2.0772763817e0)

.temp 25
Vreverse cathode 0 DC 2.5000000000e1
Ddut 0 cathode OC_NEXPERIA_BAT54L-315
.op
.end
