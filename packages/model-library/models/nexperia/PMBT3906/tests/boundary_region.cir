OpenCircuit factory test: PMBT3906-215 supported-region upper-current boundary
* OpenCircuit Model Factory v0.1.0 bulk adapter
* Original work generated from public factual specifications.
* This model is not copied or adapted from any vendor SPICE model.
* Source: https://jlcpcb.com/api/file/downloadByFileSystemAccessId/8586172665128632320
* Revision: Rev. 06 — 2 March 2010
.model OC_NEXPERIA_PMBT3906-215 PNP(IS=4.8225404777e-15 BF=2.2391112076e2 VAF=1.0000000000e2 IKF=1.4454686396e-1 ISE=1.3064653184e-15 NE=1.5000000000e0 NF=1.0000000000e0 RB=1.0000000000e1 RC=1.0000000000e-1 RE=5.0000000000e-2 CJE=1.0000000000e-12 CJC=1.0000000000e-12 TF=1.0000000000e-9)

.temp 25
IC 0 c DC -1.0000000000e-1
IB 0 b DC -3.3333333333e-3
Q1 c b 0 OC_NEXPERIA_PMBT3906-215
.op
.end
