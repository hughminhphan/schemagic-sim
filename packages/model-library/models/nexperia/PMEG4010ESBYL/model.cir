* OpenCircuit Model Factory v0.1.0 bulk adapter
* Original work generated from public factual specifications.
* This model is not copied or adapted from any vendor SPICE model.
* Source: https://jlcpcb.com/api/file/downloadByFileSystemAccessId/8588904509099945984
* Revision: PMEG4010ESB v.3, 20151127; 27 November 2015
.model OC_NEXPERIA_PMEG4010ESBYL D(IS=7.3999490392e-7 N=1.1000000000e0 RS=1.0000000000e-4)
