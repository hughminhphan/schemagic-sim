* OpenCircuit Model Factory v0.1.0 bulk adapter
* Original work generated from public factual specifications.
* This model is not copied or adapted from any vendor SPICE model.
* Source: https://jlcpcb.com/api/file/downloadByFileSystemAccessId/8586175792984567809
* Revision: Rev. 7 - 8 September 2011
.model OC_NEXPERIA_2N7002-215 VDMOS( VTO=2.0000000000e0 KP=7.1428571429e-1 THETA=0.0000000000e0 LAMBDA=3.0000000000e-3 RD=1.5400000000e0 RS=5.6000000000e-1 RG=1.0000000000e-4 RDS=1e9 CGS=2.7500000000e-11 CGDMAX=3.5000000000e-12 CGDMIN=3.5000000000e-12 CJO=3.3000000000e-12 IS=1.0000000000e-12 N=1.5000000000e0 RB=5.6000000000e-1)
