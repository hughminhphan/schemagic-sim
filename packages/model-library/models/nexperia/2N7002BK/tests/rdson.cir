OpenCircuit factory test: 2N7002BK-215 RDS(on)
* OpenCircuit Model Factory v0.1.0 bulk adapter
* Original work generated from public factual specifications.
* This model is not copied or adapted from any vendor SPICE model.
* Source: https://jlcpcb.com/api/file/downloadByFileSystemAccessId/8588884569717657600
* Revision: Rev. 1 — 17 June 2010
.model OC_NEXPERIA_2N7002BK-215 VDMOS( VTO=1.6000000000e0 KP=1.5384615385e0 THETA=0.0000000000e0 LAMBDA=3.0000000000e-3 RD=7.1500000000e-1 RS=2.6000000000e-1 RG=1.0000000000e-4 RDS=1e9 CGS=2.9000000000e-11 CGDMAX=4.0000000000e-12 CGDMIN=4.0000000000e-12 CJO=3.0000000000e-12 IS=1.0000000000e-12 N=1.5000000000e0 RB=2.6000000000e-1)

.temp 25
M1 d1 g1 0 OC_NEXPERIA_2N7002BK-215
ID1 0 d1 DC 5.0000000000e-2
VG1 g1 0 DC 5.0000000000e0
M2 d2 g2 0 OC_NEXPERIA_2N7002BK-215
ID2 0 d2 DC 5.0000000000e-2
VG2 g2 0 DC 5.0000000000e0
M3 d3 g3 0 OC_NEXPERIA_2N7002BK-215
ID3 0 d3 DC 5.0000000000e-1
VG3 g3 0 DC 1.0000000000e1
M4 d4 g4 0 OC_NEXPERIA_2N7002BK-215
ID4 0 d4 DC 5.0000000000e-1
VG4 g4 0 DC 1.0000000000e1
.op
.end
