OpenCircuit factory test: AO3401A RDS(on)
* OpenCircuit Model Factory v0.1.0
* Original work generated from public factual specifications.
* This model is not a copy of, or adaptation from, any vendor SPICE model.
* Source: https://www.aosmd.com/sites/default/files/res/data_sheets/AO3401A.pdf
* Revision: Rev. 3.1, December 2023
* Node order: drain gate source
.model OC_AO3401A VDMOS(pchan VTO=-9.2297994599e-01 KP=2.9198377694e+01 THETA=3.8576688190e-01 LAMBDA=3.0000000000e-03 RD=1.5911246170e-02 RS=8.2000000000e-03 RG=7.8000000000e+00 CGS=5.9000000000e-10 CGDMAX=1.5000000000e-10 CGDMIN=4.0000000000e-11 A=2.0000000000e-01 CJO=1.1110243022e-10 IS=1.6030000000e-08 N=1.5000000000e+00 RB=8.2000000000e-03 TT=1.5869000000e-08 BV=3.0000000000e+01 IBV=2.5000000000e-04 RTHJC=6.3000000000e+01 RTHCA=3.7000000000e+01 RDS=1e9 VJ=0.8 M=0.5 FC=0.5 NBV=1 TNOM=27)

.temp 25
M1 d1 g1 0 OC_AO3401A
I1 d1 0 4
VG1 g1 0 -10
M2 d2 g2 0 OC_AO3401A
I2 d2 0 3.5
VG2 g2 0 -4.5
M3 d3 g3 0 OC_AO3401A
I3 d3 0 2.5
VG3 g3 0 -2.5
.op
.end
