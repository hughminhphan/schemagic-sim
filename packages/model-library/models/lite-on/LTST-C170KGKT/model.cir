* OpenCircuit Model Factory v0.1.0
* Original work generated from public factual specifications.
* This model is not a copy of, or adaptation from, any vendor SPICE model.
* LTST-C170KGKT (lite-on), datasheet-fitted at 25 degC
* Archetype: archetype-diode.md, variant L
* Node order: D<ref> anode cathode OC_LITE_ON_LTST_C170KGKT
.model OC_LITE_ON_LTST_C170KGKT D(IS=6.8967221409e-21 N=2.0000000000e+00 RS=1.0000000000e-01 EG=2.1751612807e+00 TNOM=2.5000000000e+01)
