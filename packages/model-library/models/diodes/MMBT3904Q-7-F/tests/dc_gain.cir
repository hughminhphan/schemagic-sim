OpenCircuit factory test: MMBT3904Q-7-F DC gain
* OpenCircuit Model Factory v0.1.0 bulk adapter
* Original work generated from public factual specifications.
* This model is not copied or adapted from any vendor SPICE model.
* Source: https://jlcpcb.com/api/file/downloadByFileSystemAccessId/8560104975377186816
* Revision: DS45242 Rev. 1 - 2, November 2022
.model OC_DIODES-INCORPORATED_MMBT3904Q-7-F NPN(IS=1.0000000000e-14 BF=1.0677823432e2 VAF=1.0000000000e2 IKF=1.9475369370e-1 ISE=5.8498841249e-15 NE=1.5000000000e0 NF=1.0000000000e0 RB=1.0000000000e1 RC=1.0000000000e-1 RE=5.0000000000e-2 CJE=1.0000000000e-12 CJC=1.0000000000e-12 TF=1.0000000000e-9)

.temp 25
VCG1 cg1 0 DC 1.0000000000e0
IBG1 0 bg1 DC 9.5238095238e-7
QG1 cg1 bg1 0 OC_DIODES-INCORPORATED_MMBT3904Q-7-F
VCG2 cg2 0 DC 1.0000000000e0
IBG2 0 bg2 DC 9.7087378641e-6
QG2 cg2 bg2 0 OC_DIODES-INCORPORATED_MMBT3904Q-7-F
VCG3 cg3 0 DC 1.0000000000e0
IBG3 0 bg3 DC 1.0000000000e-4
QG3 cg3 bg3 0 OC_DIODES-INCORPORATED_MMBT3904Q-7-F
VCG4 cg4 0 DC 1.0000000000e0
IBG4 0 bg4 DC 2.0408163265e-4
QG4 cg4 bg4 0 OC_DIODES-INCORPORATED_MMBT3904Q-7-F
VCG5 cg5 0 DC 1.0000000000e0
IBG5 0 bg5 DC 5.8823529412e-4
QG5 cg5 bg5 0 OC_DIODES-INCORPORATED_MMBT3904Q-7-F
VCG6 cg6 0 DC 1.0000000000e0
IBG6 0 bg6 DC 1.3333333333e-3
QG6 cg6 bg6 0 OC_DIODES-INCORPORATED_MMBT3904Q-7-F
VCG7 cg7 0 DC 1.0000000000e0
IBG7 0 bg7 DC 4.0000000000e-3
QG7 cg7 bg7 0 OC_DIODES-INCORPORATED_MMBT3904Q-7-F
VCG8 cg8 0 DC 1.0000000000e0
IBG8 0 bg8 DC 2.5000000000e-6
QG8 cg8 bg8 0 OC_DIODES-INCORPORATED_MMBT3904Q-7-F
VCG9 cg9 0 DC 1.0000000000e0
IBG9 0 bg9 DC 1.4285714286e-5
QG9 cg9 bg9 0 OC_DIODES-INCORPORATED_MMBT3904Q-7-F
VCG10 cg10 0 DC 1.0000000000e0
IBG10 0 bg10 DC 1.0000000000e-4
QG10 cg10 bg10 0 OC_DIODES-INCORPORATED_MMBT3904Q-7-F
VCG11 cg11 0 DC 1.0000000000e0
IBG11 0 bg11 DC 3.3333333333e-5
QG11 cg11 bg11 0 OC_DIODES-INCORPORATED_MMBT3904Q-7-F
VCG12 cg12 0 DC 1.0000000000e0
IBG12 0 bg12 DC 8.3333333333e-4
QG12 cg12 bg12 0 OC_DIODES-INCORPORATED_MMBT3904Q-7-F
VCG13 cg13 0 DC 1.0000000000e0
IBG13 0 bg13 DC 3.3333333333e-3
QG13 cg13 bg13 0 OC_DIODES-INCORPORATED_MMBT3904Q-7-F
.op
.end
