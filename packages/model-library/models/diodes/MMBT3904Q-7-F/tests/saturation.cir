OpenCircuit factory test: MMBT3904Q-7-F saturation
* OpenCircuit Model Factory v0.1.0 bulk adapter
* Original work generated from public factual specifications.
* This model is not copied or adapted from any vendor SPICE model.
* Source: https://jlcpcb.com/api/file/downloadByFileSystemAccessId/8560104975377186816
* Revision: DS45242 Rev. 1 - 2, November 2022
.model OC_DIODES-INCORPORATED_MMBT3904Q-7-F NPN(IS=1.0000000000e-14 BF=1.0677823432e2 VAF=1.0000000000e2 IKF=1.9475369370e-1 ISE=5.8498841249e-15 NE=1.5000000000e0 NF=1.0000000000e0 RB=1.0000000000e1 RC=1.0000000000e-1 RE=5.0000000000e-2 CJE=1.0000000000e-12 CJC=1.0000000000e-12 TF=1.0000000000e-9)

.temp 25
ICS1 0 cs1 DC 1.0000000000e-2
IBS1 0 bs1 DC 1.0000000000e-3
QS1 cs1 bs1 0 OC_DIODES-INCORPORATED_MMBT3904Q-7-F
ICS2 0 cs2 DC 1.0000000000e-2
IBS2 0 bs2 DC 1.0000000000e-3
QS2 cs2 bs2 0 OC_DIODES-INCORPORATED_MMBT3904Q-7-F
ICS3 0 cs3 DC 5.0000000000e-2
IBS3 0 bs3 DC 5.0000000000e-3
QS3 cs3 bs3 0 OC_DIODES-INCORPORATED_MMBT3904Q-7-F
.op
.end
