* OpenCircuit Model Factory v0.1.0 bulk adapter
* Original work generated from public factual specifications.
* This model is not copied or adapted from any vendor SPICE model.
* Source: https://jlcpcb.com/api/file/downloadByFileSystemAccessId/8560104975377186816
* Revision: DS45242 Rev. 1 - 2, November 2022
.model OC_DIODES-INCORPORATED_MMBT3904Q-7-F NPN(IS=1.0000000000e-14 BF=1.0677823432e2 VAF=1.0000000000e2 IKF=1.9475369370e-1 ISE=5.8498841249e-15 NE=1.5000000000e0 NF=1.0000000000e0 RB=1.0000000000e1 RC=1.0000000000e-1 RE=5.0000000000e-2 CJE=1.0000000000e-12 CJC=1.0000000000e-12 TF=1.0000000000e-9)
