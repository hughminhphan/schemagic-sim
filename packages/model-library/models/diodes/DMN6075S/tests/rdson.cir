OpenCircuit factory test: DMN6075S-7 RDS(on)
* OpenCircuit Model Factory v0.1.0 bulk adapter
* Original work generated from public factual specifications.
* This model is not copied or adapted from any vendor SPICE model.
* Source: https://jlcpcb.com/api/file/downloadByFileSystemAccessId/8560080310105755648
* Revision: DS37023 Rev. 6 - 2, May 2018
.model OC_DIODES-INCORPORATED_DMN6075S-7 VDMOS( VTO=3.0000000000e0 KP=2.8985507246e1 THETA=0.0000000000e0 LAMBDA=3.0000000000e-3 RD=3.7950000000e-2 RS=1.3800000000e-2 RG=1.0000000000e-4 RDS=1e9 CGS=5.8140000000e-10 CGDMAX=2.4600000000e-11 CGDMIN=2.4600000000e-11 CJO=8.0000000000e-12 IS=1.0000000000e-12 N=1.5000000000e0 RB=1.3800000000e-2)

.temp 25
M1 d1 g1 0 OC_DIODES-INCORPORATED_DMN6075S-7
ID1 0 d1 DC 3.2000000000e0
VG1 g1 0 DC 1.0000000000e1
.op
.end
