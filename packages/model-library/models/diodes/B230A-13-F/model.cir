* OpenCircuit Model Factory v0.1.0 bulk adapter
* Original work generated from public factual specifications.
* This model is not copied or adapted from any vendor SPICE model.
* Source: https://jlcpcb.com/api/file/downloadByFileSystemAccessId/8560078861175455744
* Revision: DS13004 Rev. 22 - 2, July 2015
.model OC_DIODES-INCORPORATED_B230A-13-F D(IS=4.1638626105e-6 N=1.1000000000e0 RS=1.0000000000e-4)
