* OpenCircuit Model Factory v0.1.0 bulk adapter
* Original work generated from public factual specifications.
* This model is not copied or adapted from any vendor SPICE model.
* Source: https://jlcpcb.com/api/file/downloadByFileSystemAccessId/8560082258184478720
* Revision: 11-2
.model OC_DIODES-INCORPORATED_DMC2400UV-7 VDMOS( VTO=9.0000000000e-1 KP=6.6666666667e0 THETA=0.0000000000e0 LAMBDA=3.0000000000e-3 RD=1.6500000000e-1 RS=6.0000000000e-2 RG=1.0000000000e-4 RDS=1e9 CGS=3.2300000000e-11 CGDMAX=4.8000000000e-12 CGDMIN=4.8000000000e-12 CJO=1.7000000000e-12 IS=1.0000000000e-12 N=1.5000000000e0 RB=6.0000000000e-2)
