Batch 9 independent review: FMMT624TA exact gain hard bounds
* Public datasheet facts only; no vendor SPICE model used.
.model OC_DIODES-INCORPORATED_FMMT624TA NPN(IS=1.0000000000e-14 BF=4.5000000000e2 VAF=1.0000000000e2 IKF=1.0000000000e3 RB=1.0000000000e1 RC=1.0000000000e-1 RE=5.0000000000e-2 CJE=1.0000000000e-12 CJC=1.0000000000e-12 TF=1.0000000000e-9)

.temp 25
VCG1 cg1 0 DC 10
IBG1 0 bg1 DC 2.0334750273526421e-05
QG1 cg1 bg1 0 OC_DIODES-INCORPORATED_FMMT624TA
VCG2 cg2 0 DC 10
IBG2 0 bg2 DC 0.00040715907546397723
QG2 cg2 bg2 0 OC_DIODES-INCORPORATED_FMMT624TA
VCG3 cg3 0 DC 10
IBG3 0 bg3 DC 0.0020403075294646729
QG3 cg3 bg3 0 OC_DIODES-INCORPORATED_FMMT624TA
.op
.end
