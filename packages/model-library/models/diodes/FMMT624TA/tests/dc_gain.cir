OpenCircuit factory test: FMMT624TA DC gain
* OpenCircuit Model Factory v0.1.0 bulk adapter
* Original work generated from public factual specifications.
* This model is not copied or adapted from any vendor SPICE model.
* Source: https://jlcpcb.com/api/file/downloadByFileSystemAccessId/8588880655975387136
* Revision: DS33110 Rev. 5 - 2, December 2012
.model OC_DIODES-INCORPORATED_FMMT624TA NPN(IS=1.0000000000e-14 BF=4.5000000000e2 VAF=1.0000000000e2 IKF=1.0000000000e3 RB=1.0000000000e1 RC=1.0000000000e-1 RE=5.0000000000e-2 CJE=1.0000000000e-12 CJC=1.0000000000e-12 TF=1.0000000000e-9)

.temp 25
VCG1 cg1 0 DC 1.0000000000e1
IBG1 0 bg1 DC 5.0000000000e-5
QG1 cg1 bg1 0 OC_DIODES-INCORPORATED_FMMT624TA
VCG2 cg2 0 DC 1.0000000000e1
IBG2 0 bg2 DC 6.6666666667e-4
QG2 cg2 bg2 0 OC_DIODES-INCORPORATED_FMMT624TA
VCG3 cg3 0 DC 1.0000000000e1
IBG3 0 bg3 DC 1.0000000000e-2
QG3 cg3 bg3 0 OC_DIODES-INCORPORATED_FMMT624TA
VCG4 cg4 0 DC 1.0000000000e1
IBG4 0 bg4 DC 4.4444444444e-4
QG4 cg4 bg4 0 OC_DIODES-INCORPORATED_FMMT624TA
.op
.end
