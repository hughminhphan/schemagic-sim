OpenCircuit factory test: forward_01.cir
* OpenCircuit Model Factory v0.1.0 bulk adapter
* Original work generated from public factual specifications.
* This model is not copied or adapted from any vendor SPICE model.
* Source: https://jlcpcb.com/api/file/downloadByFileSystemAccessId/8560105754431541248
* Revision: DS13012 Rev. 18 - 2, March 2023
.model OC_DIODES-INCORPORATED_B540C-13-F D(IS=2.5551434700e-7 N=1.1000000000e0 RS=1.0000000000e-4)

.temp 2.5000000000e1
Itest 0 anode DC 5.0000000000e0
Vanchor anchor 0 DC 0
Ranchor anchor 0 1G
Ddut anode 0 OC_DIODES-INCORPORATED_B540C-13-F
.op
.end
