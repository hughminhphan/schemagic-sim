* OpenCircuit Model Factory v0.1.0 bulk adapter
* Original work generated from public factual specifications.
* This model is not copied or adapted from any vendor SPICE model.
* Source: https://jlcpcb.com/api/file/downloadByFileSystemAccessId/8560080352284082176
* Revision: DS37996 Rev. 3-2, July 2023
.model OC_DIODES-INCORPORATED_DMN6140LQ-7 VDMOS( VTO=3.0000000000e0 KP=2.1739130435e1 THETA=0.0000000000e0 LAMBDA=3.0000000000e-3 RD=5.0600000000e-2 RS=1.8400000000e-2 RG=1.0000000000e-4 RDS=1e9 CGS=2.9900000000e-10 CGDMAX=1.6000000000e-11 CGDMIN=1.6000000000e-11 CJO=2.0000000000e-12 IS=1.0000000000e-12 N=1.5000000000e0 RB=1.8400000000e-2)
