* OpenCircuit Model Factory v0.1.0 bulk adapter
* Original work generated from public factual specifications.
* This model is not copied or adapted from any vendor SPICE model.
* Source: https://jlcpcb.com/api/file/downloadByFileSystemAccessId/8560091436261019648
* Revision: DS38480 Rev. 2 - 2, July 2021
.model OC_DIODES-INCORPORATED_DMN2056U-7 VDMOS( VTO=6.0000000000e-1 KP=6.6666666667e1 THETA=0.0000000000e0 LAMBDA=3.0000000000e-3 RD=1.6500000000e-2 RS=6.0000000000e-3 RG=1.0000000000e-4 RDS=1e9 CGS=3.0500000000e-10 CGDMAX=3.4000000000e-11 CGDMIN=3.4000000000e-11 CJO=1.3000000000e-11 IS=1.0000000000e-12 N=1.5000000000e0 RB=6.0000000000e-3)
