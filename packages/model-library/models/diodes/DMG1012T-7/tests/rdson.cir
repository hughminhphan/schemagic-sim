OpenCircuit factory test: DMG1012T-7 RDS(on)
* OpenCircuit Model Factory v0.1.0 bulk adapter
* Original work generated from public factual specifications.
* This model is not copied or adapted from any vendor SPICE model.
* Source: https://jlcpcb.com/api/file/downloadByFileSystemAccessId/8586202438936776704
* Revision: DS31783 Rev. 8 - 2, February 2022
.model OC_DIODES-INCORPORATED_DMG1012T-7 VDMOS( VTO=1.0000000000e0 KP=6.6666666667e0 THETA=0.0000000000e0 LAMBDA=3.0000000000e-3 RD=1.6500000000e-1 RS=6.0000000000e-2 RG=1.0000000000e-4 RDS=1e9 CGS=5.5300000000e-11 CGDMAX=5.3700000000e-12 CGDMIN=5.3700000000e-12 CJO=4.3100000000e-12 IS=1.0000000000e-12 N=1.5000000000e0 RB=6.0000000000e-2)

.temp 25
M1 d1 g1 0 OC_DIODES-INCORPORATED_DMG1012T-7
ID1 0 d1 DC 6.0000000000e-1
VG1 g1 0 DC 4.5000000000e0
M2 d2 g2 0 OC_DIODES-INCORPORATED_DMG1012T-7
ID2 0 d2 DC 6.0000000000e-1
VG2 g2 0 DC 4.5000000000e0
M3 d3 g3 0 OC_DIODES-INCORPORATED_DMG1012T-7
ID3 0 d3 DC 5.0000000000e-1
VG3 g3 0 DC 2.5000000000e0
M4 d4 g4 0 OC_DIODES-INCORPORATED_DMG1012T-7
ID4 0 d4 DC 5.0000000000e-1
VG4 g4 0 DC 2.5000000000e0
M5 d5 g5 0 OC_DIODES-INCORPORATED_DMG1012T-7
ID5 0 d5 DC 3.5000000000e-1
VG5 g5 0 DC 1.8000000000e0
M6 d6 g6 0 OC_DIODES-INCORPORATED_DMG1012T-7
ID6 0 d6 DC 3.5000000000e-1
VG6 g6 0 DC 1.8000000000e0
.op
.end
