* OpenCircuit Model Factory v0.1.0 bulk adapter
* Original work generated from public factual specifications.
* This model is not copied or adapted from any vendor SPICE model.
* Source: https://jlcpcb.com/api/file/downloadByFileSystemAccessId/8586202438936776704
* Revision: DS31783 Rev. 8 - 2, February 2022
.model OC_DIODES-INCORPORATED_DMG1012T-7 VDMOS( VTO=1.0000000000e0 KP=6.6666666667e0 THETA=0.0000000000e0 LAMBDA=3.0000000000e-3 RD=1.6500000000e-1 RS=6.0000000000e-2 RG=1.0000000000e-4 RDS=1e9 CGS=5.5300000000e-11 CGDMAX=5.3700000000e-12 CGDMIN=5.3700000000e-12 CJO=4.3100000000e-12 IS=1.0000000000e-12 N=1.5000000000e0 RB=6.0000000000e-2)
