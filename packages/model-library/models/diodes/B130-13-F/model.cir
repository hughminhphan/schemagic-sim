* OpenCircuit Model Factory v0.1.0 bulk adapter
* Original work generated from public factual specifications.
* This model is not copied or adapted from any vendor SPICE model.
* Source: https://jlcpcb.com/api/file/downloadByFileSystemAccessId/8560078983225507840
* Revision: datasheet as supplied
.model OC_DIODES-INCORPORATED_B130-13-F D(IS=3.3595193918e-8 N=1.1000000000e0 RS=1.0000000000e-4)
