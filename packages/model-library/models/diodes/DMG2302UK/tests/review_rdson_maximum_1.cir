OpenCircuit independent review hard-bound probe
* OpenCircuit Model Factory v0.1.0 bulk adapter
* Original work generated from public factual specifications.
* This model is not copied or adapted from any vendor SPICE model.
* Source: https://jlcpcb.com/api/file/downloadByFileSystemAccessId/8588885238898024449
* Revision: Document number DS38439 Rev. 2 - 2, January 2016
.model OC_DIODES-INCORPORATED_DMG2302UK-7 VDMOS( VTO=6.0000000000e-1 KP=3.2786885246e1 THETA=0.0000000000e0 LAMBDA=3.0000000000e-3 RD=3.3550000000e-2 RS=1.2200000000e-2 RG=1.0000000000e-4 RDS=1e9 CGS=1.1200000000e-10 CGDMAX=1.8000000000e-11 CGDMIN=1.8000000000e-11 CJO=8.0000000000e-12 IS=1.0000000000e-12 N=1.5000000000e0 RB=1.2200000000e-2)
.temp 25
M1 d g 0 OC_DIODES-INCORPORATED_DMG2302UK-7
ID 0 d DC 3.600000000000e+0
VG g 0 DC 4.500000000000e+0
.op
.end
