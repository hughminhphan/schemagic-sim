* OpenCircuit Model Factory v0.1.0 bulk adapter
* Original work generated from public factual specifications.
* This model is not copied or adapted from any vendor SPICE model.
* Source: https://jlcpcb.com/api/file/downloadByFileSystemAccessId/8586197557579669504
* Revision: DS38627 Rev. 4 - 2, December 2024
.model OC_DIODES-INCORPORATED_DFLS1150Q-7 D(IS=5.7071211878e-13 N=1.1000000000e0 RS=1.0000000000e-4)
