* OpenCircuit Model Factory v0.1.0 bulk adapter
* Original work generated from public factual specifications.
* This model is not copied or adapted from any vendor SPICE model.
* Source: https://jlcpcb.com/api/file/downloadByFileSystemAccessId/8586181025684316160
* Revision: v1.1
.model OC_WUXI-NCE-POWER-SEMICONDUCTOR_NCE3407 VDMOS( pchan VTO=-1.5000000000e0 KP=4.1666666667e1 THETA=0.0000000000e0 LAMBDA=3.0000000000e-3 RD=2.6400000000e-2 RS=9.6000000000e-3 RG=1.0000000000e-4 RDS=1e9 CGS=5.8500000000e-10 CGDMAX=6.5000000000e-11 CGDMIN=6.5000000000e-11 CJO=4.0000000000e-11 IS=1.0000000000e-12 N=1.5000000000e0 RB=9.6000000000e-3)
