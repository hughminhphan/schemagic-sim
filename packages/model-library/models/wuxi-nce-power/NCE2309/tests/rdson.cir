OpenCircuit factory test: NCE2309 RDS(on)
* OpenCircuit Model Factory v0.1.0 bulk adapter
* Original work generated from public factual specifications.
* This model is not copied or adapted from any vendor SPICE model.
* Source: https://jlcpcb.com/api/file/downloadByFileSystemAccessId/8588907130916622336
* Revision: v2.0
.model OC_WUXI-NCE-POWER-SEMICONDUCTOR_NCE2309 VDMOS( pchan VTO=-2.0000000000e0 KP=1.4285714286e1 THETA=0.0000000000e0 LAMBDA=3.0000000000e-3 RD=7.7000000000e-2 RS=2.8000000000e-2 RG=1.0000000000e-4 RDS=1e9 CGS=3.6500000000e-10 CGDMAX=5.0000000000e-12 CGDMIN=5.0000000000e-12 CJO=2.6500000000e-11 IS=1.0000000000e-12 N=1.5000000000e0 RB=2.8000000000e-2)

.temp 25
M1 d1 g1 0 OC_WUXI-NCE-POWER-SEMICONDUCTOR_NCE2309
ID1 d1 0 DC 1.5000000000e0
VG1 g1 0 DC -1.0000000000e1
.op
.end
