OpenCircuit factory test: 2N7002K-T1-GE3 RDS(on)
* OpenCircuit Model Factory v0.1.0 bulk adapter
* Original work generated from public factual specifications.
* This model is not copied or adapted from any vendor SPICE model.
* Source: https://jlcpcb.com/api/file/downloadByFileSystemAccessId/8586176217846321152
* Revision: S09-0857-Rev. E, 18-May-09
.model OC_VISHAY-INTERTECH_2N7002K-T1-GE3 VDMOS( VTO=2.0000000000e0 KP=1.0000000000e0 THETA=0.0000000000e0 LAMBDA=3.0000000000e-3 RD=1.1000000000e0 RS=4.0000000000e-1 RG=1.0000000000e-4 RDS=1e9 CGS=2.7500000000e-11 CGDMAX=2.5000000000e-12 CGDMIN=2.5000000000e-12 CJO=3.5000000000e-12 IS=1.0000000000e-12 N=1.5000000000e0 RB=4.0000000000e-1)

.temp 25
M1 d1 g1 0 OC_VISHAY-INTERTECH_2N7002K-T1-GE3
ID1 0 d1 DC 5.0000000000e-1
VG1 g1 0 DC 1.0000000000e1
M2 d2 g2 0 OC_VISHAY-INTERTECH_2N7002K-T1-GE3
ID2 0 d2 DC 2.0000000000e-1
VG2 g2 0 DC 4.5000000000e0
.op
.end
