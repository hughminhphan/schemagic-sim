* OpenCircuit Model Factory v0.1.0 bulk adapter
* Original work generated from public factual specifications.
* This model is not copied or adapted from any vendor SPICE model.
* Source: https://jlcpcb.com/api/file/downloadByFileSystemAccessId/8586176217846321152
* Revision: S09-0857-Rev. E, 18-May-09
.model OC_VISHAY-INTERTECH_2N7002K-T1-GE3 VDMOS( VTO=2.0000000000e0 KP=1.0000000000e0 THETA=0.0000000000e0 LAMBDA=3.0000000000e-3 RD=1.1000000000e0 RS=4.0000000000e-1 RG=1.0000000000e-4 RDS=1e9 CGS=2.7500000000e-11 CGDMAX=2.5000000000e-12 CGDMIN=2.5000000000e-12 CJO=3.5000000000e-12 IS=1.0000000000e-12 N=1.5000000000e0 RB=4.0000000000e-1)
