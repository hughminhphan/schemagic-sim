OpenCircuit factory test: forward_01.cir
* OpenCircuit Model Factory v0.1.0 bulk adapter
* Original work generated from public factual specifications.
* This model is not copied or adapted from any vendor SPICE model.
* Source: https://jlcpcb.com/api/file/downloadByFileSystemAccessId/8588881707499442177
* Revision: Rev. 1.9, 27-Mar-13
.model OC_VISHAY-INTERTECH_LL4148-GS08 D(IS=2.3229909400e-11 N=1.8000000000e0 RS=1.0000000000e-4)

.temp 25
Itest 0 anode DC 4.7500000000e-2
Vanchor anchor 0 DC 0
Ranchor anchor 0 1G
Ddut anode 0 OC_VISHAY-INTERTECH_LL4148-GS08
.op
.end
