OpenCircuit factory test: forward_05.cir
* OpenCircuit Model Factory v0.1.0
* Original work generated from public factual specifications.
* This model is not a copy of, or adaptation from, any vendor SPICE model.
* Source: https://datasheet.octopart.com/BAT85-Vishay-datasheet-28185.pdf
* Revision: BAT85 Rev. 1.3, 31-Mar-2004; archived Vishay PDF mirror
* Fit: scipy.optimize.least_squares at 25 degC
.model OC_VISHAY_BAT85 D(IS=1.7237509335e-8 N=1.0673076793e0 RS=3.6083882666e0 CJO=1.0000000000e-11 TNOM=2.5000000000e1)

Itest 0 anode DC 1.0000000000e-1
Vanchor anchor 0 DC 0
Ranchor anchor 0 1G
Ddut anode 0 OC_VISHAY_BAT85
.op
.end
