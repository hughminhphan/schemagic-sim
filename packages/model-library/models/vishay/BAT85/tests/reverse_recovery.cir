OpenCircuit factory test: reverse recovery
* OpenCircuit Model Factory v0.1.0
* Original work generated from public factual specifications.
* This model is not a copy of, or adaptation from, any vendor SPICE model.
* Source: https://datasheet.octopart.com/BAT85-Vishay-datasheet-28185.pdf
* Revision: BAT85 Rev. 1.3, 31-Mar-2004; archived Vishay PDF mirror
* Fit: scipy.optimize.least_squares at 25 degC
.model OC_VISHAY_BAT85 D(IS=1.4333461173e-8 N=1.0673076793e0 RS=3.6083882666e0 CJO=1.0000000000e-11 TT=5.0000000000e-9)

Vdrive src 0 PULSE(1.7 -6 20n 0.1n 0.1n 20n 50n)
Rload src anode 100
Ddut anode 0 OC_VISHAY_BAT85
.tran 0.05n 50n
.end
