OpenCircuit factory test: SI2302 body diode
* OpenCircuit Model Factory v0.1.0
* Original work generated from public factual specifications.
* This model is not a copy of, or adaptation from, any vendor SPICE model.
* Source: https://www.vishay.com/docs/63653/si2302dds.pdf
* Revision: S11-2528-Rev. A, 26-Dec-2011
* Node order: drain gate source
.model OC_SI2302 VDMOS(VTO=8.4489237475e-01 KP=2.0381438626e+01 THETA=1.5415906565e-03 LAMBDA=3.0000000000e-03 RD=1.6177173474e-02 RS=9.0000000000e-03 RG=4.0000000000e+00 CGS=3.0000000000e-10 CGDMAX=3.5000000000e-11 CGDMIN=1.0000000000e-11 A=2.5000000000e-01 CJO=1.6000000000e-10 IS=1.6900000000e-08 N=1.5000000000e+00 RB=9.0000000000e-03 TT=1.2262900000e-08 BV=2.0000000000e+01 IBV=2.5000000000e-04 RTHJC=6.2000000000e+01 RTHCA=7.8000000000e+01 RDS=1e9 VJ=0.8 M=0.5 FC=0.5 NBV=1 TNOM=27)
.temp 25
M1 d g 0 OC_SI2302
IB d 0 0.95
VG g 0 0
.op
.end
