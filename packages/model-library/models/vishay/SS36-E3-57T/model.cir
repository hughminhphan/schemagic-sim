* OpenCircuit Model Factory v0.1.0 bulk adapter
* Original work generated from public factual specifications.
* This model is not copied or adapted from any vendor SPICE model.
* Source: https://jlcpcb.com/api/file/downloadByFileSystemAccessId/8579707595575525376
* Revision: 04-Aug-15
.model OC_VISHAY-INTERTECH_SS36-E3-57T D(IS=3.3724317581e-6 N=1.2173151307e0 RS=1.0654372616e-2)
