OpenCircuit independent review hard-bound probe
* OpenCircuit Model Factory v0.1.0 bulk adapter
* Original work generated from public factual specifications.
* This model is not copied or adapted from any vendor SPICE model.
* Source: https://jlcpcb.com/api/file/downloadByFileSystemAccessId/8588904401713180672
* Revision: Revision not stated in supplied datasheet
.model OC_HX-HENGJIAXING_HX2301A VDMOS( pchan VTO=-7.0000000000e-1 KP=1.7857142857e1 THETA=0.0000000000e0 LAMBDA=3.0000000000e-3 RD=6.1600000000e-2 RS=2.2400000000e-2 RG=1.0000000000e-4 RDS=1e9 CGS=2.8800000000e-10 CGDMAX=3.7000000000e-11 CGDMIN=3.7000000000e-11 CJO=2.6000000000e-11 IS=1.0000000000e-12 N=1.5000000000e0 RB=2.2400000000e-2)
.temp 25
M1 d g 0 OC_HX-HENGJIAXING_HX2301A
ID d 0 DC 1.800000000000e+0
VG g 0 DC -4.500000000000e+0
.op
.end
