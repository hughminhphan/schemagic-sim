OpenCircuit independent review hard-bound probe
* OpenCircuit Model Factory v0.1.0 bulk adapter
* Original work generated from public factual specifications.
* This model is not copied or adapted from any vendor SPICE model.
* Source: https://jlcpcb.com/api/file/downloadByFileSystemAccessId/8586177149288263680
* Revision: Rev. 02, dated 09/12/2011
.model OC_ST-SEMTECH_MMFTN3019E VDMOS( VTO=1.5000000000e0 KP=2.7777777778e-1 THETA=0.0000000000e0 LAMBDA=3.0000000000e-3 RD=3.9600000000e0 RS=1.4400000000e0 RG=1.0000000000e-4 RDS=1e9 CGS=9.0000000000e-12 CGDMAX=4.0000000000e-12 CGDMIN=4.0000000000e-12 CJO=5.0000000000e-12 IS=1.0000000000e-12 N=1.5000000000e0 RB=1.4400000000e0)
.temp 25
M1 d g 0 OC_ST-SEMTECH_MMFTN3019E
ID 0 d DC 1.000000000000e-3
VG g 0 DC 2.500000000000e+0
.op
.end
