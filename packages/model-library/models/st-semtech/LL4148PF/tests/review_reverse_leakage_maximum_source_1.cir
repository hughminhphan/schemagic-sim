OpenCircuit independent review hard-bound probe
* OpenCircuit Model Factory v0.1.0 bulk adapter
* Original work generated from public factual specifications.
* This model is not copied or adapted from any vendor SPICE model.
* Source: https://jlcpcb.com/api/file/downloadByFileSystemAccessId/8589836936899821568
* Revision: Rev. 02, dated 09/12/2021
.model OC_ST-SEMTECH_LL4148PF D(IS=4.2458856850e-9 N=1.9519026633e0 RS=4.7662278821e-1)
.temp 25
Vreverse cathode 0 DC 2.000000000000e+01
Ddut 0 cathode OC_ST-SEMTECH_LL4148PF
.op
.end
