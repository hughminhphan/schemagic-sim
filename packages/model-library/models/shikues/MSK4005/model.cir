* OpenCircuit Model Factory v0.1.0 bulk adapter
* Original work generated from public factual specifications.
* This model is not copied or adapted from any vendor SPICE model.
* Source: https://jlcpcb.com/api/file/downloadByFileSystemAccessId/8757070748924432384
* Revision: REV.08
.model OC_SHIKUES_MSK4005 D(IS=8.6763862243e-8 N=1.1000000000e0 RS=1.0000000000e-4)
