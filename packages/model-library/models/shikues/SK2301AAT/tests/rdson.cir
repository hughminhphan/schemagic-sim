OpenCircuit factory test: SK2301AAT RDS(on)
* OpenCircuit Model Factory v0.1.0 bulk adapter
* Original work generated from public factual specifications.
* This model is not copied or adapted from any vendor SPICE model.
* Source: https://jlcpcb.com/api/file/downloadByFileSystemAccessId/8590906258411376640
* Revision: REV.08
.model OC_SHIKUES_SK2301AAT VDMOS( pchan VTO=-6.2000000000e-1 KP=1.5384615385e1 THETA=0.0000000000e0 LAMBDA=3.0000000000e-3 RD=7.1500000000e-2 RS=2.6000000000e-2 RG=1.0000000000e-4 RDS=1e9 CGS=2.6100000000e-10 CGDMAX=2.9000000000e-11 CGDMIN=2.9000000000e-11 CJO=1.8000000000e-11 IS=1.0000000000e-12 N=1.5000000000e0 RB=2.6000000000e-2)

.temp 25
M1 d1 g1 0 OC_SHIKUES_SK2301AAT
ID1 d1 0 DC 2.3000000000e0
VG1 g1 0 DC -4.5000000000e0
M2 d2 g2 0 OC_SHIKUES_SK2301AAT
ID2 d2 0 DC 2.3000000000e0
VG2 g2 0 DC -4.5000000000e0
M3 d3 g3 0 OC_SHIKUES_SK2301AAT
ID3 d3 0 DC 1.5000000000e0
VG3 g3 0 DC -2.5000000000e0
M4 d4 g4 0 OC_SHIKUES_SK2301AAT
ID4 d4 0 DC 1.5000000000e0
VG4 g4 0 DC -2.5000000000e0
M5 d5 g5 0 OC_SHIKUES_SK2301AAT
ID5 d5 0 DC 1.5000000000e0
VG5 g5 0 DC -1.8000000000e0
.op
.end
