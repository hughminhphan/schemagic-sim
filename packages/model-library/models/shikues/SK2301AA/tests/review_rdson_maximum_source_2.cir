OpenCircuit independent review hard-bound probe
* OpenCircuit Model Factory v0.1.0 bulk adapter
* Original work generated from public factual specifications.
* This model is not copied or adapted from any vendor SPICE model.
* Source: https://jlcpcb.com/api/file/downloadByFileSystemAccessId/8757070089433042944
* Revision: REV.08
.model OC_SHIKUES_SK2301AA VDMOS( pchan VTO=-1.0000000000e0 KP=1.8518518519e1 THETA=0.0000000000e0 LAMBDA=3.0000000000e-3 RD=5.9400000000e-2 RS=2.1600000000e-2 RG=1.0000000000e-4 RDS=1e9 CGS=9.5000000000e-10 CGDMAX=5.0000000000e-11 CGDMIN=5.0000000000e-11 CJO=1.5000000000e-10 IS=1.0000000000e-12 N=1.5000000000e0 RB=2.1600000000e-2)
.temp 25
M1 d g 0 OC_SHIKUES_SK2301AA
ID d 0 DC 2.0
VG g 0 DC -2.5
.op
.end
