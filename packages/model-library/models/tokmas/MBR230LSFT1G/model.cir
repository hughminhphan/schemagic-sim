* OpenCircuit Model Factory v0.1.0 bulk adapter
* Original work generated from public factual specifications.
* This model is not copied or adapted from any vendor SPICE model.
* Source: https://jlcpcb.com/api/file/downloadByFileSystemAccessId/8590903022270959616
* Revision: revision not stated in source
.model OC_TOKMAS_MBR230LSFT1G D(IS=2.0652641049e-6 N=1.1000000000e0 RS=1.0000000000e-4)
