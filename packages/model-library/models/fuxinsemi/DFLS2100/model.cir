* OpenCircuit Model Factory v0.1.0 bulk adapter
* Original work generated from public factual specifications.
* This model is not copied or adapted from any vendor SPICE model.
* Source: https://jlcpcb.com/api/file/downloadByFileSystemAccessId/8590233066871283712
* Revision: Ver2.1
.model OC_FUXINSEMI_DFLS2100 D(IS=2.0736960670e-9 N=1.1000000000e0 RS=1.0000000000e-4)
