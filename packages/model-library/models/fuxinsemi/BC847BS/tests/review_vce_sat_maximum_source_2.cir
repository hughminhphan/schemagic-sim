OpenCircuit independent review hard-bound probe
* OpenCircuit Model Factory v0.1.0 bulk adapter
* Original work generated from public factual specifications.
* This model is not copied or adapted from any vendor SPICE model.
* Source: https://jlcpcb.com/api/file/downloadByFileSystemAccessId/8590904630807785472
* Revision: Ver2.1
.model OC_FUXINSEMI_BC847BS NPN(IS=1.0000000000e-14 BF=2.0200000000e2 VAF=1.0000000000e2 IKF=1.0000000000e3 RB=1.0000000000e1 RC=1.0000000000e-1 RE=5.0000000000e-2 CJE=1.0000000000e-12 CJC=1.0000000000e-12 TF=1.0000000000e-9)
.temp 25
IC 0 c DC 0.1
IB 0 b DC 0.005
Q c b 0 OC_FUXINSEMI_BC847BS
.op
.end
