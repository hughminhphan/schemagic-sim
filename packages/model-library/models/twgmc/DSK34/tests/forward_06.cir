OpenCircuit factory test: forward_06.cir
* OpenCircuit Model Factory v0.1.0 bulk adapter
* Original work generated from public factual specifications.
* This model is not copied or adapted from any vendor SPICE model.
* Source: https://jlcpcb.com/api/file/downloadByFileSystemAccessId/8588893855869505536
* Revision: Not stated
.model OC_TWGMC_DSK34 D(IS=1.3425913515e-5 N=1.7351211370e0 RS=8.6697276348e-3)

.temp 25
Itest 0 anode DC 2.0000000000e1
Vanchor anchor 0 DC 0
Ranchor anchor 0 1G
Ddut anode 0 OC_TWGMC_DSK34
.op
.end
