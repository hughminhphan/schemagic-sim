* OpenCircuit Model Factory v0.1.0 bulk adapter
* Original work generated from public factual specifications.
* This model is not copied or adapted from any vendor SPICE model.
* Source: https://jlcpcb.com/api/file/downloadByFileSystemAccessId/8590903089631481856
* Revision: V 1.1
.model OC_MDD-MICRODIODE-SEMICONDUCTOR_BSS123 VDMOS( VTO=1.8000000000e0 KP=6.6666666667e-1 THETA=0.0000000000e0 LAMBDA=3.0000000000e-3 RD=1.6500000000e0 RS=6.0000000000e-1 RG=1.0000000000e-4 RDS=1e9 CGS=2.5000000000e-11 CGDMAX=7.0000000000e-12 CGDMIN=7.0000000000e-12 CJO=3.0000000000e-12 IS=1.0000000000e-12 N=1.5000000000e0 RB=6.0000000000e-1)
