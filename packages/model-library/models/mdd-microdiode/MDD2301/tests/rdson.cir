OpenCircuit factory test: MDD2301 RDS(on)
* OpenCircuit Model Factory v0.1.0 bulk adapter
* Original work generated from public factual specifications.
* This model is not copied or adapted from any vendor SPICE model.
* Source: https://jlcpcb.com/api/file/downloadByFileSystemAccessId/8588907458819461120
* Revision: V 1.2
.model OC_MDD-MICRODIODE-SEMICONDUCTOR_MDD2301 VDMOS( pchan VTO=-7.0000000000e-1 KP=6.0606060606e1 THETA=0.0000000000e0 LAMBDA=3.0000000000e-3 RD=1.8150000000e-2 RS=6.6000000000e-3 RG=1.0000000000e-4 RDS=1e9 CGS=2.8500000000e-10 CGDMAX=4.5000000000e-11 CGDMIN=4.5000000000e-11 CJO=5.0000000000e-12 IS=1.0000000000e-12 N=1.5000000000e0 RB=6.6000000000e-3)

.temp 25
M1 d1 g1 0 OC_MDD-MICRODIODE-SEMICONDUCTOR_MDD2301
ID1 d1 0 DC 3.0000000000e0
VG1 g1 0 DC -4.5000000000e0
M2 d2 g2 0 OC_MDD-MICRODIODE-SEMICONDUCTOR_MDD2301
ID2 d2 0 DC 2.0000000000e0
VG2 g2 0 DC -2.5000000000e0
.op
.end
