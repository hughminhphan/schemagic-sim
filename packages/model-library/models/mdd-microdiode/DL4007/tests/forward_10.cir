OpenCircuit factory test: forward_10.cir
* OpenCircuit Model Factory v0.1.0 bulk adapter
* Original work generated from public factual specifications.
* This model is not copied or adapted from any vendor SPICE model.
* Source: https://jlcpcb.com/api/file/downloadByFileSystemAccessId/8586175681742426112
* Revision: Rev:2024A2
.model OC_MDD-MICRODIODE-SEMICONDUCTOR_DL4007 D(IS=2.9383909206e-8 N=2.1132451294e0 RS=4.3718083996e-2)

.temp 25
Itest 0 anode DC 4.0000000000e0
Vanchor anchor 0 DC 0
Ranchor anchor 0 1G
Ddut anode 0 OC_MDD-MICRODIODE-SEMICONDUCTOR_DL4007
.op
.end
