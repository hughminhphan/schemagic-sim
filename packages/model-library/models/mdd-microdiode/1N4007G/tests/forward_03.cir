OpenCircuit factory test: forward_03.cir
* OpenCircuit Model Factory v0.1.0 bulk adapter
* Original work generated from public factual specifications.
* This model is not copied or adapted from any vendor SPICE model.
* Source: https://jlcpcb.com/api/file/downloadByFileSystemAccessId/8588887223848603648
* Revision: Rev: 2024A2
.model OC_MDD-MICRODIODE-SEMICONDUCTOR_1N4007G D(IS=6.0443264157e-6 N=3.1798774696e0 RS=1.7614256177e-2)

.temp 25
Itest 0 anode DC 1.0000000000e-1
Vanchor anchor 0 DC 0
Ranchor anchor 0 1G
Ddut anode 0 OC_MDD-MICRODIODE-SEMICONDUCTOR_1N4007G
.op
.end
