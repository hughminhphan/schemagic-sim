OpenCircuit independent review: published BJT saturation hard bounds
* OpenCircuit Model Factory v0.1.0 bulk adapter
* Original work generated from public factual specifications.
* This model is not copied or adapted from any vendor SPICE model.
* Source: https://jlcpcb.com/api/file/downloadByFileSystemAccessId/8604433861119909888
* Revision: Rev:2024A1
.model OC_MDD-MICRODIODE-SEMICONDUCTOR_S9013-E NPN(IS=1.0000000000e-14 BF=2.4000000000e2 VAF=1.0000000000e2 IKF=1.0000000000e3 RB=1.0000000000e1 RC=1.0000000000e-1 RE=5.0000000000e-2 CJE=1.0000000000e-12 CJC=1.0000000000e-12 TF=1.0000000000e-9)

.temp 25
IC1 0 c1 DC 0.5
IB1 0 b1 DC 0.05
Q1 c1 b1 0 OC_MDD-MICRODIODE-SEMICONDUCTOR_S9013-E
.op
.end
