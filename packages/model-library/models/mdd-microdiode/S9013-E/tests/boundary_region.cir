OpenCircuit factory test: S9013-E supported-region upper-current boundary
* OpenCircuit Model Factory v0.1.0 bulk adapter
* Original work generated from public factual specifications.
* This model is not copied or adapted from any vendor SPICE model.
* Source: https://jlcpcb.com/api/file/downloadByFileSystemAccessId/8604433861119909888
* Revision: Rev:2024A1
.model OC_MDD-MICRODIODE-SEMICONDUCTOR_S9013-E NPN(IS=1.0000000000e-14 BF=2.4000000000e2 VAF=1.0000000000e2 IKF=1.0000000000e3 RB=1.0000000000e1 RC=1.0000000000e-1 RE=5.0000000000e-2 CJE=1.0000000000e-12 CJC=1.0000000000e-12 TF=1.0000000000e-9)

.temp 25
IC 0 c DC 5.0000000000e-2
IB 0 b DC 4.1666666667e-4
Q1 c b 0 OC_MDD-MICRODIODE-SEMICONDUCTOR_S9013-E
.op
.end
