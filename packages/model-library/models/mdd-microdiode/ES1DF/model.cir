* OpenCircuit Model Factory v0.1.0 bulk adapter
* Original work generated from public factual specifications.
* This model is not copied or adapted from any vendor SPICE model.
* Source: https://jlcpcb.com/api/file/downloadByFileSystemAccessId/8586194509189287936
* Revision: Rev:2024A1
.model OC_MDD-MICRODIODE-SEMICONDUCTOR_ES1DF D(IS=3.9104891474e-12 N=1.8000000000e0 RS=1.0000000000e-4)
