OpenCircuit factory test: forward_02.cir
* OpenCircuit Model Factory v0.1.0 bulk adapter
* Original work generated from public factual specifications.
* This model is not copied or adapted from any vendor SPICE model.
* Source: https://jlcpcb.com/api/file/downloadByFileSystemAccessId/8588883633633431552
* Revision: Rev. 2024A2
.model OC_MDD-MICRODIODE-SEMICONDUCTOR_1N4007WS D(IS=1.1006910425e-8 N=1.9390006038e0 RS=2.6556152885e-2)

.temp 25
Itest 0 anode DC 2.0000000000e-1
Vanchor anchor 0 DC 0
Ranchor anchor 0 1G
Ddut anode 0 OC_MDD-MICRODIODE-SEMICONDUCTOR_1N4007WS
.op
.end
