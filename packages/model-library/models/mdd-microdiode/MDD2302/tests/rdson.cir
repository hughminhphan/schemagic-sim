OpenCircuit factory test: MDD2302 RDS(on)
* OpenCircuit Model Factory v0.1.0 bulk adapter
* Original work generated from public factual specifications.
* This model is not copied or adapted from any vendor SPICE model.
* Source: https://jlcpcb.com/api/file/downloadByFileSystemAccessId/8588906188805722112
* Revision: V1.1
.model OC_MDD-MICRODIODE-SEMICONDUCTOR_MDD2302 VDMOS( VTO=8.0000000000e-1 KP=8.0000000000e1 THETA=0.0000000000e0 LAMBDA=3.0000000000e-3 RD=1.3750000000e-2 RS=5.0000000000e-3 RG=1.0000000000e-4 RDS=1e9 CGS=3.0700000000e-10 CGDMAX=3.3000000000e-11 CGDMIN=3.3000000000e-11 CJO=8.2000000000e-11 IS=1.0000000000e-12 N=1.5000000000e0 RB=5.0000000000e-3)

.temp 25
M1 d1 g1 0 OC_MDD-MICRODIODE-SEMICONDUCTOR_MDD2302
ID1 0 d1 DC 4.0000000000e0
VG1 g1 0 DC 4.5000000000e0
M2 d2 g2 0 OC_MDD-MICRODIODE-SEMICONDUCTOR_MDD2302
ID2 0 d2 DC 3.0000000000e0
VG2 g2 0 DC 2.5000000000e0
.op
.end
