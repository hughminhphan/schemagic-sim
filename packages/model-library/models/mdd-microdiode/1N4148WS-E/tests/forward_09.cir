OpenCircuit factory test: forward_09.cir
* OpenCircuit Model Factory v0.1.0 bulk adapter
* Original work generated from public factual specifications.
* This model is not copied or adapted from any vendor SPICE model.
* Source: https://jlcpcb.com/api/file/downloadByFileSystemAccessId/8604432959844077568
* Revision: Rev:2024A1
.model OC_MDD-MICRODIODE-SEMICONDUCTOR_1N4148WS-E D(IS=1.8636114728e-12 N=1.0541615033e0 RS=1.4663928208e0)

.temp 25
Itest 0 anode DC 1.0000000000e-2
Vanchor anchor 0 DC 0
Ranchor anchor 0 1G
Ddut anode 0 OC_MDD-MICRODIODE-SEMICONDUCTOR_1N4148WS-E
.op
.end
