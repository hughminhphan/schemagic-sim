* OpenCircuit Model Factory v0.1.0 bulk adapter
* Original work generated from public factual specifications.
* This model is not copied or adapted from any vendor SPICE model.
* Source: https://jlcpcb.com/api/file/downloadByFileSystemAccessId/8586172488225337344
* Revision: datasheet as supplied
.model OC_MDD-MICRODIODE-SEMICONDUCTOR_SS54C D(IS=3.0605247996e-8 N=1.1000000000e0 RS=1.0000000000e-4)
