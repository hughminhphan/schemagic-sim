OpenCircuit factory test: MDD50N03D RDS(on)
* OpenCircuit Model Factory v0.1.0 bulk adapter
* Original work generated from public factual specifications.
* This model is not copied or adapted from any vendor SPICE model.
* Source: https://jlcpcb.com/api/file/downloadByFileSystemAccessId/8590903079678263296
* Revision: V 1.0
.model OC_MDD-MICRODIODE-SEMICONDUCTOR_MDD50N03D VDMOS( VTO=1.5000000000e0 KP=3.0769230769e2 THETA=0.0000000000e0 LAMBDA=3.0000000000e-3 RD=3.5750000000e-3 RS=1.3000000000e-3 RG=1.0000000000e-4 RDS=1e9 CGS=8.5100000000e-10 CGDMAX=1.6400000000e-10 CGDMIN=1.6400000000e-10 CJO=3.7000000000e-11 IS=1.0000000000e-12 N=1.5000000000e0 RB=1.3000000000e-3)

.temp 25
M1 d1 g1 0 OC_MDD-MICRODIODE-SEMICONDUCTOR_MDD50N03D
ID1 0 d1 DC 2.0000000000e1
VG1 g1 0 DC 1.0000000000e1
M2 d2 g2 0 OC_MDD-MICRODIODE-SEMICONDUCTOR_MDD50N03D
ID2 0 d2 DC 2.0000000000e1
VG2 g2 0 DC 1.0000000000e1
M3 d3 g3 0 OC_MDD-MICRODIODE-SEMICONDUCTOR_MDD50N03D
ID3 0 d3 DC 1.5000000000e1
VG3 g3 0 DC 4.5000000000e0
M4 d4 g4 0 OC_MDD-MICRODIODE-SEMICONDUCTOR_MDD50N03D
ID4 0 d4 DC 1.5000000000e1
VG4 g4 0 DC 4.5000000000e0
.op
.end
