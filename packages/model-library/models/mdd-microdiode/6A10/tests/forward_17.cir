OpenCircuit factory test: forward_17.cir
* OpenCircuit Model Factory v0.1.0 bulk adapter
* Original work generated from public factual specifications.
* This model is not copied or adapted from any vendor SPICE model.
* Source: https://jlcpcb.com/api/file/downloadByFileSystemAccessId/8588887223840215041
* Revision: Rev:2024A2
.model OC_MDD-MICRODIODE-SEMICONDUCTOR_6A10 D(IS=7.4541575779e-6 N=2.5317164741e0 RS=1.5064898714e-3)

.temp 25
Itest 0 anode DC 6.0000000000e0
Vanchor anchor 0 DC 0
Ranchor anchor 0 1G
Ddut anode 0 OC_MDD-MICRODIODE-SEMICONDUCTOR_6A10
.op
.end
