OpenCircuit factory test: reverse leakage
* OpenCircuit Model Factory v0.1.0 bulk adapter
* Original work generated from public factual specifications.
* This model is not copied or adapted from any vendor SPICE model.
* Source: https://jlcpcb.com/api/file/downloadByFileSystemAccessId/8588887223840215041
* Revision: Rev:2024A2
.model OC_MDD-MICRODIODE-SEMICONDUCTOR_6A10 D(IS=7.4541575779e-6 N=2.5317164741e0 RS=1.5064898714e-3)

.temp 25
Vreverse cathode 0 DC 1.0000000000e3
Ddut 0 cathode OC_MDD-MICRODIODE-SEMICONDUCTOR_6A10
.op
.end
