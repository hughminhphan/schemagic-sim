OpenCircuit factory test: forward_01.cir
* OpenCircuit Model Factory v0.1.0 bulk adapter
* Original work generated from public factual specifications.
* This model is not copied or adapted from any vendor SPICE model.
* Source: https://jlcpcb.com/api/file/downloadByFileSystemAccessId/8586175619906613248
* Revision: Rev. 2024A3
.model OC_MDD-MICRODIODE-SEMICONDUCTOR_SM4007PL D(IS=6.1583305304e-8 N=2.1781580995e0 RS=6.4517310454e-4)

.temp 25
Itest 0 anode DC 1.0000000000e-1
Vanchor anchor 0 DC 0
Ranchor anchor 0 1G
Ddut anode 0 OC_MDD-MICRODIODE-SEMICONDUCTOR_SM4007PL
.op
.end
