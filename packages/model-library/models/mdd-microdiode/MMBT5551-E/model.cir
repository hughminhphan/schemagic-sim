* OpenCircuit Model Factory v0.1.0 bulk adapter
* Original work generated from public factual specifications.
* This model is not copied or adapted from any vendor SPICE model.
* Source: https://jlcpcb.com/api/file/downloadByFileSystemAccessId/8604433306284793856
* Revision: Rev:2024A1
.model OC_MDD-MICRODIODE-SEMICONDUCTOR_MMBT5551-E NPN(IS=1.0000000000e-14 BF=4.0459215560e2 VAF=1.0000000000e2 IKF=2.7686540028e-2 ISE=1.5279556931e-13 NE=1.5000000000e0 NF=1.0000000000e0 RB=1.0000000000e1 RC=1.0000000000e-1 RE=5.0000000000e-2 CJE=1.0000000000e-12 CJC=1.0000000000e-12 TF=1.0000000000e-9)
