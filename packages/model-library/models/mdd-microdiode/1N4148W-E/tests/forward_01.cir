OpenCircuit factory test: forward_01.cir
* OpenCircuit Model Factory v0.1.0 bulk adapter
* Original work generated from public factual specifications.
* This model is not copied or adapted from any vendor SPICE model.
* Source: https://jlcpcb.com/api/file/downloadByFileSystemAccessId/8604432959751397376
* Revision: Rev:2024A1
.model OC_MDD-MICRODIODE-SEMICONDUCTOR_1N4148W-E D(IS=2.4988135705e-13 N=1.1769524665e0 RS=7.5729493081e-1)

.temp 25
Itest 0 anode DC 1.0000000000e-4
Vanchor anchor 0 DC 0
Ranchor anchor 0 1G
Ddut anode 0 OC_MDD-MICRODIODE-SEMICONDUCTOR_1N4148W-E
.op
.end
