OpenCircuit factory test: MMBT3904-E DC gain
* OpenCircuit Model Factory v0.1.0 bulk adapter
* Original work generated from public factual specifications.
* This model is not copied or adapted from any vendor SPICE model.
* Source: https://jlcpcb.com/api/file/downloadByFileSystemAccessId/8604434048337133568
* Revision: Rev:2024A1
.model OC_MDD-MICRODIODE-SEMICONDUCTOR_MMBT3904-E NPN(IS=1.0000000000e-14 BF=2.8100176373e2 VAF=1.0000000000e2 IKF=3.0261360690e-2 ISE=2.4603668703e-14 NE=1.5000000000e0 NF=1.0000000000e0 RB=1.0000000000e1 RC=1.0000000000e-1 RE=5.0000000000e-2 CJE=1.0000000000e-12 CJC=1.0000000000e-12 TF=1.0000000000e-9)

.temp 25
VCG1 cg1 0 DC 1.0000000000e0
IBG1 0 bg1 DC 4.5454545455e-7
QG1 cg1 bg1 0 OC_MDD-MICRODIODE-SEMICONDUCTOR_MMBT3904-E
VCG2 cg2 0 DC 1.0000000000e0
IBG2 0 bg2 DC 1.3452914798e-6
QG2 cg2 bg2 0 OC_MDD-MICRODIODE-SEMICONDUCTOR_MMBT3904-E
VCG3 cg3 0 DC 1.0000000000e0
IBG3 0 bg3 DC 4.4444444444e-6
QG3 cg3 bg3 0 OC_MDD-MICRODIODE-SEMICONDUCTOR_MMBT3904-E
VCG4 cg4 0 DC 1.0000000000e0
IBG4 0 bg4 DC 1.3333333333e-5
QG4 cg4 bg4 0 OC_MDD-MICRODIODE-SEMICONDUCTOR_MMBT3904-E
VCG5 cg5 0 DC 1.0000000000e0
IBG5 0 bg5 DC 4.5454545455e-5
QG5 cg5 bg5 0 OC_MDD-MICRODIODE-SEMICONDUCTOR_MMBT3904-E
VCG6 cg6 0 DC 1.0000000000e0
IBG6 0 bg6 DC 1.9354838710e-4
QG6 cg6 bg6 0 OC_MDD-MICRODIODE-SEMICONDUCTOR_MMBT3904-E
VCG7 cg7 0 DC 1.0000000000e0
IBG7 0 bg7 DC 1.8181818182e-3
QG7 cg7 bg7 0 OC_MDD-MICRODIODE-SEMICONDUCTOR_MMBT3904-E
VCG8 cg8 0 DC 1.0000000000e0
IBG8 0 bg8 DC 1.0000000000e-4
QG8 cg8 bg8 0 OC_MDD-MICRODIODE-SEMICONDUCTOR_MMBT3904-E
VCG9 cg9 0 DC 1.0000000000e0
IBG9 0 bg9 DC 3.3333333333e-5
QG9 cg9 bg9 0 OC_MDD-MICRODIODE-SEMICONDUCTOR_MMBT3904-E
VCG10 cg10 0 DC 1.0000000000e0
IBG10 0 bg10 DC 8.3333333333e-4
QG10 cg10 bg10 0 OC_MDD-MICRODIODE-SEMICONDUCTOR_MMBT3904-E
VCG11 cg11 0 DC 1.0000000000e0
IBG11 0 bg11 DC 3.3333333333e-3
QG11 cg11 bg11 0 OC_MDD-MICRODIODE-SEMICONDUCTOR_MMBT3904-E
.op
.end
