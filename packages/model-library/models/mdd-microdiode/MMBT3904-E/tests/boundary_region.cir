OpenCircuit factory test: MMBT3904-E supported-region upper-current boundary
* OpenCircuit Model Factory v0.1.0 bulk adapter
* Original work generated from public factual specifications.
* This model is not copied or adapted from any vendor SPICE model.
* Source: https://jlcpcb.com/api/file/downloadByFileSystemAccessId/8604434048337133568
* Revision: Rev:2024A1
.model OC_MDD-MICRODIODE-SEMICONDUCTOR_MMBT3904-E NPN(IS=1.0000000000e-14 BF=2.8100176373e2 VAF=1.0000000000e2 IKF=3.0261360690e-2 ISE=2.4603668703e-14 NE=1.5000000000e0 NF=1.0000000000e0 RB=1.0000000000e1 RC=1.0000000000e-1 RE=5.0000000000e-2 CJE=1.0000000000e-12 CJC=1.0000000000e-12 TF=1.0000000000e-9)

.temp 25
IC 0 c DC 1.0000000000e-1
IB 0 b DC 1.8181818182e-3
Q1 c b 0 OC_MDD-MICRODIODE-SEMICONDUCTOR_MMBT3904-E
.op
.end
