OpenCircuit factory test: forward_09.cir
* OpenCircuit Model Factory v0.1.0 bulk adapter
* Original work generated from public factual specifications.
* This model is not copied or adapted from any vendor SPICE model.
* Source: https://jlcpcb.com/api/file/downloadByFileSystemAccessId/8588887223857532928
* Revision: Rev:2024A3
.model OC_MDD-MICRODIODE-SEMICONDUCTOR_10A10 D(IS=1.6817841712e-7 N=1.9812446847e0 RS=1.6598627952e-3)

.temp 2.5000000000e1
Itest 0 anode PULSE(0 5.0000000000e1 3.0000000000e-4 3.0000000000e-7 3.0000000000e-7 3.0000000000e-4 3.0000000000e-2)
Vanchor anchor 0 DC 0
Ranchor anchor 0 1G
Ddut anode 0 OC_MDD-MICRODIODE-SEMICONDUCTOR_10A10
.tran 7.5000000000e-6 5.2530000000e-4
.end
