OpenCircuit independent review hard-bound probe
* OpenCircuit Model Factory v0.1.0 bulk adapter
* Original work generated from public factual specifications.
* This model is not copied or adapted from any vendor SPICE model.
* Source: https://jlcpcb.com/api/file/downloadByFileSystemAccessId/8757105908256256000
* Revision: Rev:2025A5
.model OC_MDD-MICRODIODE-SEMICONDUCTOR_BAV21W D(IS=2.0721703338e-11 N=1.5452331666e0 RS=4.9913792831e-1)
.temp 25
Itest 0 anode DC 2.000000000000e-01
Vanchor anchor 0 DC 0
Ranchor anchor 0 1G
Ddut anode 0 OC_MDD-MICRODIODE-SEMICONDUCTOR_BAV21W
.op
.end
