OpenCircuit factory test: 2SC3356 DC gain
* OpenCircuit Model Factory v0.1.0 bulk adapter
* Original work generated from public factual specifications.
* This model is not copied or adapted from any vendor SPICE model.
* Source: https://jlcpcb.com/api/file/downloadByFileSystemAccessId/8588918618939252736
* Revision: Not stated in PDF
.model OC_GUANGDONG-HOTTECH_2SC3356 NPN(IS=1.0000000000e-14 BF=1.1739674110e2 VAF=1.0000000000e2 IKF=4.8784104650e-1 ISE=2.6578821224e-14 NE=1.5000000000e0 NF=1.0000000000e0 RB=1.0000000000e1 RC=1.0000000000e-1 RE=5.0000000000e-2 CJE=1.0000000000e-12 CJC=1.0000000000e-12 TF=1.0000000000e-9)

.temp 25
VCG1 cg1 0 DC 1.0000000000e1
IBG1 0 bg1 DC 4.2372881356e-6
QG1 cg1 bg1 0 OC_GUANGDONG-HOTTECH_2SC3356
VCG2 cg2 0 DC 1.0000000000e1
IBG2 0 bg2 DC 8.3333333333e-6
QG2 cg2 bg2 0 OC_GUANGDONG-HOTTECH_2SC3356
VCG3 cg3 0 DC 1.0000000000e1
IBG3 0 bg3 DC 1.6528925620e-5
QG3 cg3 bg3 0 OC_GUANGDONG-HOTTECH_2SC3356
VCG4 cg4 0 DC 1.0000000000e1
IBG4 0 bg4 DC 4.0983606557e-5
QG4 cg4 bg4 0 OC_GUANGDONG-HOTTECH_2SC3356
VCG5 cg5 0 DC 1.0000000000e1
IBG5 0 bg5 DC 8.1967213115e-5
QG5 cg5 bg5 0 OC_GUANGDONG-HOTTECH_2SC3356
VCG6 cg6 0 DC 1.0000000000e1
IBG6 0 bg6 DC 1.6528925620e-4
QG6 cg6 bg6 0 OC_GUANGDONG-HOTTECH_2SC3356
VCG7 cg7 0 DC 1.0000000000e1
IBG7 0 bg7 DC 4.3478260870e-4
QG7 cg7 bg7 0 OC_GUANGDONG-HOTTECH_2SC3356
VCG8 cg8 0 DC 1.0000000000e1
IBG8 0 bg8 DC 4.0000000000e-4
QG8 cg8 bg8 0 OC_GUANGDONG-HOTTECH_2SC3356
VCG9 cg9 0 DC 1.0000000000e1
IBG9 0 bg9 DC 1.6666666667e-4
QG9 cg9 bg9 0 OC_GUANGDONG-HOTTECH_2SC3356
VCG10 cg10 0 DC 1.0000000000e1
IBG10 0 bg10 DC 6.6666666667e-5
QG10 cg10 bg10 0 OC_GUANGDONG-HOTTECH_2SC3356
VCG11 cg11 0 DC 1.0000000000e1
IBG11 0 bg11 DC 4.2372881356e-6
QG11 cg11 bg11 0 OC_GUANGDONG-HOTTECH_2SC3356
VCG12 cg12 0 DC 1.0000000000e1
IBG12 0 bg12 DC 8.3333333333e-6
QG12 cg12 bg12 0 OC_GUANGDONG-HOTTECH_2SC3356
VCG13 cg13 0 DC 1.0000000000e1
IBG13 0 bg13 DC 4.0983606557e-5
QG13 cg13 bg13 0 OC_GUANGDONG-HOTTECH_2SC3356
VCG14 cg14 0 DC 1.0000000000e1
IBG14 0 bg14 DC 8.1967213115e-5
QG14 cg14 bg14 0 OC_GUANGDONG-HOTTECH_2SC3356
VCG15 cg15 0 DC 1.0000000000e1
IBG15 0 bg15 DC 1.6528925620e-4
QG15 cg15 bg15 0 OC_GUANGDONG-HOTTECH_2SC3356
VCG16 cg16 0 DC 1.0000000000e1
IBG16 0 bg16 DC 4.3478260870e-4
QG16 cg16 bg16 0 OC_GUANGDONG-HOTTECH_2SC3356
.op
.end
