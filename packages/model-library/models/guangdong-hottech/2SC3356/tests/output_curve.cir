OpenCircuit factory test: 2SC3356 output sanity
* OpenCircuit Model Factory v0.1.0 bulk adapter
* Original work generated from public factual specifications.
* This model is not copied or adapted from any vendor SPICE model.
* Source: https://jlcpcb.com/api/file/downloadByFileSystemAccessId/8588918618939252736
* Revision: Not stated in PDF
.model OC_GUANGDONG-HOTTECH_2SC3356 NPN(IS=1.0000000000e-14 BF=1.1739674110e2 VAF=1.0000000000e2 IKF=4.8784104650e-1 ISE=2.6578821224e-14 NE=1.5000000000e0 NF=1.0000000000e0 RB=1.0000000000e1 RC=1.0000000000e-1 RE=5.0000000000e-2 CJE=1.0000000000e-12 CJC=1.0000000000e-12 TF=1.0000000000e-9)

.temp 25
VCE1 c1 0 DC 2
IB1 0 b1 DC 0.00001
Q1 c1 b1 0 OC_GUANGDONG-HOTTECH_2SC3356
VCE2 c2 0 DC 10
IB2 0 b2 DC 0.00005
Q2 c2 b2 0 OC_GUANGDONG-HOTTECH_2SC3356
.op
.end
