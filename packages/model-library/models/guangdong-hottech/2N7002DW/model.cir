* OpenCircuit Model Factory v0.1.0 bulk adapter
* Original work generated from public factual specifications.
* This model is not copied or adapted from any vendor SPICE model.
* Source: https://jlcpcb.com/api/file/downloadByFileSystemAccessId/8590902445445107712
* Revision: 1
.model OC_GUANGDONG-HOTTECH_2N7002DW VDMOS( VTO=1.5000000000e0 KP=1.0526315789e0 THETA=0.0000000000e0 LAMBDA=3.0000000000e-3 RD=1.0450000000e0 RS=3.8000000000e-1 RG=1.0000000000e-4 RDS=1e9 CGS=1.1200000000e-11 CGDMAX=8.0000000000e-13 CGDMIN=8.0000000000e-13 CJO=2.4000000000e-12 IS=1.0000000000e-12 N=1.5000000000e0 RB=3.8000000000e-1)
