OpenCircuit independent review hard-bound probe
* OpenCircuit Model Factory v0.1.0 bulk adapter
* Original work generated from public factual specifications.
* This model is not copied or adapted from any vendor SPICE model.
* Source: https://jlcpcb.com/api/file/downloadByFileSystemAccessId/8588905223956148224
* Revision: unspecified
.model OC_GUANGDONG-HOTTECH_4953 VDMOS( pchan VTO=-1.6000000000e0 KP=4.6511627907e1 THETA=0.0000000000e0 LAMBDA=3.0000000000e-3 RD=2.3650000000e-2 RS=8.6000000000e-3 RG=1.0000000000e-4 RDS=1e9 CGS=4.5000000000e-10 CGDMAX=7.0000000000e-11 CGDMIN=7.0000000000e-11 CJO=6.0000000000e-11 IS=1.0000000000e-12 N=1.5000000000e0 RB=8.6000000000e-3)
.temp 25
M1 d g 0 OC_GUANGDONG-HOTTECH_4953
ID d 0 DC 5.1
VG g 0 DC -10.0
.op
.end
