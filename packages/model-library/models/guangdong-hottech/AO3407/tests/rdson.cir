OpenCircuit factory test: AO3407 RDS(on)
* OpenCircuit Model Factory v0.1.0 bulk adapter
* Original work generated from public factual specifications.
* This model is not copied or adapted from any vendor SPICE model.
* Source: https://jlcpcb.com/api/file/downloadByFileSystemAccessId/8586187899393462272
* Revision: Revision not stated in supplied PDF
.model OC_GUANGDONG-HOTTECH_AO3407 VDMOS( pchan VTO=-3.0000000000e0 KP=3.3333333333e1 THETA=0.0000000000e0 LAMBDA=3.0000000000e-3 RD=3.3000000000e-2 RS=1.2000000000e-2 RG=1.0000000000e-4 RDS=1e9 CGS=6.2500000000e-10 CGDMAX=7.5000000000e-11 CGDMIN=7.5000000000e-11 CJO=4.5000000000e-11 IS=1.0000000000e-12 N=1.5000000000e0 RB=1.2000000000e-2)

.temp 25
M1 d1 g1 0 OC_GUANGDONG-HOTTECH_AO3407
ID1 d1 0 DC 4.1000000000e0
VG1 g1 0 DC -1.0000000000e1
M2 d2 g2 0 OC_GUANGDONG-HOTTECH_AO3407
ID2 d2 0 DC 3.0000000000e0
VG2 g2 0 DC -4.5000000000e0
.op
.end
