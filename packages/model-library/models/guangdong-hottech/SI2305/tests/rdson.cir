OpenCircuit factory test: SI2305 RDS(on)
* OpenCircuit Model Factory v0.1.0 bulk adapter
* Original work generated from public factual specifications.
* This model is not copied or adapted from any vendor SPICE model.
* Source: https://jlcpcb.com/api/file/downloadByFileSystemAccessId/8586189681994174464
* Revision: Revision not stated in supplied PDF
.model OC_GUANGDONG-HOTTECH_SI2305 VDMOS( pchan VTO=-9.0000000000e-1 KP=4.4444444444e1 THETA=0.0000000000e0 LAMBDA=3.0000000000e-3 RD=2.4750000000e-2 RS=9.0000000000e-3 RG=1.0000000000e-4 RDS=1e9 CGS=5.5000000000e-10 CGDMAX=1.9000000000e-10 CGDMIN=1.9000000000e-10 CJO=1.0000000000e-10 IS=1.0000000000e-12 N=1.5000000000e0 RB=9.0000000000e-3)

.temp 25
M1 d1 g1 0 OC_GUANGDONG-HOTTECH_SI2305
ID1 d1 0 DC 3.5000000000e0
VG1 g1 0 DC -4.5000000000e0
M2 d2 g2 0 OC_GUANGDONG-HOTTECH_SI2305
ID2 d2 0 DC 3.0000000000e0
VG2 g2 0 DC -2.5000000000e0
M3 d3 g3 0 OC_GUANGDONG-HOTTECH_SI2305
ID3 d3 0 DC 2.0000000000e0
VG3 g3 0 DC -1.8000000000e0
.op
.end
