OpenCircuit independent review hard-bound probe
* OpenCircuit Model Factory v0.1.0 bulk adapter
* Original work generated from public factual specifications.
* This model is not copied or adapted from any vendor SPICE model.
* Source: https://jlcpcb.com/api/file/downloadByFileSystemAccessId/8550723919347523584
* Revision: Rev. not stated
.model OC_GUANGDONG-HOTTECH_1N5819WS D(IS=9.1359773665e-5 N=1.8375541199e0 RS=4.8313962752e-2)
.temp 25
Vreverse cathode 0 DC 4.000000000000e+01
Ddut 0 cathode OC_GUANGDONG-HOTTECH_1N5819WS
.op
.end
