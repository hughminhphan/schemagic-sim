OpenCircuit factory test: forward_05.cir
* OpenCircuit Model Factory v0.1.0 bulk adapter
* Original work generated from public factual specifications.
* This model is not copied or adapted from any vendor SPICE model.
* Source: https://jlcpcb.com/api/file/downloadByFileSystemAccessId/8550723919347523584
* Revision: Rev. not stated
.model OC_GUANGDONG-HOTTECH_1N5819WS D(IS=9.1359773665e-5 N=1.8375541199e0 RS=4.8313962752e-2)

.temp 25
Itest 0 anode DC 6.0000000000e-1
Vanchor anchor 0 DC 0
Ranchor anchor 0 1G
Ddut anode 0 OC_GUANGDONG-HOTTECH_1N5819WS
.op
.end
