* OpenCircuit Model Factory v0.1.0 bulk adapter
* Original work generated from public factual specifications.
* This model is not copied or adapted from any vendor SPICE model.
* Source: https://jlcpcb.com/api/file/downloadByFileSystemAccessId/8588918822799204352
* Revision: Not stated
.model OC_GUANGDONG-HOTTECH_SS24L D(IS=6.7416623209e-8 N=1.1000000000e0 RS=1.0000000000e-4)
