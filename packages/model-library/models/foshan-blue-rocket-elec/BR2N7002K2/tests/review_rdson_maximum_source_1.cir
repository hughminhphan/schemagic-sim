OpenCircuit independent review hard-bound probe
* OpenCircuit Model Factory v0.1.0 bulk adapter
* Original work generated from public factual specifications.
* This model is not copied or adapted from any vendor SPICE model.
* Source: https://jlcpcb.com/api/file/downloadByFileSystemAccessId/8588884459952857088
* Revision: Rev.C Aug.-2018
.model OC_FOSHAN-BLUE-ROCKET-ELEC_BR2N7002K2 VDMOS( VTO=1.6000000000e0 KP=1.1764705882e0 THETA=0.0000000000e0 LAMBDA=3.0000000000e-3 RD=9.3500000000e-1 RS=3.4000000000e-1 RG=1.0000000000e-4 RDS=1e9 CGS=4.5000000000e-11 CGDMAX=5.0000000000e-12 CGDMIN=5.0000000000e-12 CJO=2.0000000000e-11 IS=1.0000000000e-12 N=1.5000000000e0 RB=3.4000000000e-1)
.temp 25
M1 d g 0 OC_FOSHAN-BLUE-ROCKET-ELEC_BR2N7002K2
ID 0 d DC 0.5
VG g 0 DC 10.0
.op
.end
