OpenCircuit factory test: forward_02.cir
* OpenCircuit Model Factory v0.1.0 bulk adapter
* Original work generated from public factual specifications.
* This model is not copied or adapted from any vendor SPICE model.
* Source: https://jlcpcb.com/api/file/downloadByFileSystemAccessId/8603067504960942080
* Revision: Rev:1.1
.model OC_ZHUHAI-HONGJIACHENG-TECHNOLOGY-CO.-LTD_ES1M D(IS=1.6667671026e-12 N=2.0814835215e0 RS=1.0994778251e-2)

.temp 25
Itest 0 anode DC 1.0000000000e-1
Vanchor anchor 0 DC 0
Ranchor anchor 0 1G
Ddut anode 0 OC_ZHUHAI-HONGJIACHENG-TECHNOLOGY-CO.-LTD_ES1M
.op
.end
