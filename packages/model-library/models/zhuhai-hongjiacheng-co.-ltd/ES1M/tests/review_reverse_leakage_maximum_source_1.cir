OpenCircuit independent review hard-bound probe
* OpenCircuit Model Factory v0.1.0 bulk adapter
* Original work generated from public factual specifications.
* This model is not copied or adapted from any vendor SPICE model.
* Source: https://jlcpcb.com/api/file/downloadByFileSystemAccessId/8603067504960942080
* Revision: Rev:1.1
.model OC_ZHUHAI-HONGJIACHENG-TECHNOLOGY-CO.-LTD_ES1M D(IS=1.6667671026e-12 N=2.0814835215e0 RS=1.0994778251e-2)
.temp 25
Vreverse cathode 0 DC 1.000000000000e+03
Ddut 0 cathode OC_ZHUHAI-HONGJIACHENG-TECHNOLOGY-CO.-LTD_ES1M
.op
.end
