* OpenCircuit Model Factory v0.1.0 bulk adapter
* Original work generated from public factual specifications.
* This model is not copied or adapted from any vendor SPICE model.
* Source: https://jlcpcb.com/api/file/downloadByFileSystemAccessId/8603353239119417344
* Revision: not stated in PDF
.model OC_JSMSEMI_SI2301-A1SHB VDMOS( pchan VTO=-1.0000000000e0 KP=2.2222222222e1 THETA=0.0000000000e0 LAMBDA=3.0000000000e-3 RD=4.9500000000e-2 RS=1.8000000000e-2 RG=1.0000000000e-4 RDS=1e9 CGS=3.5000000000e-10 CGDMAX=5.5000000000e-11 CGDMIN=5.5000000000e-11 CJO=2.0000000000e-11 IS=1.0000000000e-12 N=1.5000000000e0 RB=1.8000000000e-2)
