* OpenCircuit Model Factory v0.1.0 bulk adapter
* Original work generated from public factual specifications.
* This model is not copied or adapted from any vendor SPICE model.
* Source: https://jlcpcb.com/api/file/downloadByFileSystemAccessId/8603178061366521856
* Revision: Revision not stated in supplied PDF
.model OC_JSMSEMI_AOD407 VDMOS( pchan VTO=-2.5000000000e0 KP=3.2679738562e1 THETA=0.0000000000e0 LAMBDA=3.0000000000e-3 RD=3.3660000000e-2 RS=1.2240000000e-2 RG=1.0000000000e-4 RDS=1e9 CGS=1.3750000000e-9 CGDMAX=6.5000000000e-11 CGDMIN=6.5000000000e-11 CJO=3.2000000000e-11 IS=1.0000000000e-12 N=1.5000000000e0 RB=1.2240000000e-2)
