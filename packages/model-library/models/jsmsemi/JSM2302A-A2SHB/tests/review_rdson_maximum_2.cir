OpenCircuit independent review hard-bound probe
* OpenCircuit Model Factory v0.1.0 bulk adapter
* Original work generated from public factual specifications.
* This model is not copied or adapted from any vendor SPICE model.
* Source: https://jlcpcb.com/api/file/downloadByFileSystemAccessId/8588945034095419392
* Revision: No revision stated; datasheet page footer www.jsmsemi.com
.model OC_JSMSEMI_JSM2302A-A2SHB VDMOS( VTO=1.0000000000e0 KP=3.7037037037e1 THETA=0.0000000000e0 LAMBDA=3.0000000000e-3 RD=2.9700000000e-2 RS=1.0800000000e-2 RG=1.0000000000e-4 RDS=1e9 CGS=9.5000000000e-10 CGDMAX=5.0000000000e-11 CGDMIN=5.0000000000e-11 CJO=1.5000000000e-10 IS=1.0000000000e-12 N=1.5000000000e0 RB=1.0800000000e-2)
.temp 25
M1 d g 0 OC_JSMSEMI_JSM2302A-A2SHB
ID 0 d DC 3.100000000000e+0
VG g 0 DC 2.500000000000e+0
.op
.end
