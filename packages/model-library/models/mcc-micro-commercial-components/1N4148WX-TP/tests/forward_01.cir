OpenCircuit factory test: forward_01.cir
* OpenCircuit Model Factory v0.1.0 bulk adapter
* Original work generated from public factual specifications.
* This model is not copied or adapted from any vendor SPICE model.
* Source: https://jlcpcb.com/api/file/downloadByFileSystemAccessId/8588883963851255808
* Revision: Revision F, 2016/10/28
.model OC_MCC-MICRO-COMMERCIAL-COMPONENTS_1N4148WX-TP D(IS=3.6951365918e-11 N=1.8000000000e0 RS=1.0000000000e-4)

.temp 2.5000000000e1
Itest 0 anode DC 5.0000000000e-2
Vanchor anchor 0 DC 0
Ranchor anchor 0 1G
Ddut anode 0 OC_MCC-MICRO-COMMERCIAL-COMPONENTS_1N4148WX-TP
.op
.end
