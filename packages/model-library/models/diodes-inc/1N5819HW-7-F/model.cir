* OpenCircuit Model Factory v0.1.0 bulk adapter
* Original work generated from public factual specifications.
* This model is not copied or adapted from any vendor SPICE model.
* Source: https://jlcpcb.com/api/file/downloadByFileSystemAccessId/8560106692622254080
* Revision: DS30217 Rev. 21 - 2, April 2023
.model OC_DIODES-INCORPORATED_1N5819HW-7-F D(IS=1.2970072572e-6 N=1.1000000000e0 RS=1.0000000000e-4)
