OpenCircuit factory test: forward_18.cir
* OpenCircuit Model Factory v0.1.0 bulk adapter
* Original work generated from public factual specifications.
* This model is not copied or adapted from any vendor SPICE model.
* Source: https://jlcpcb.com/api/file/downloadByFileSystemAccessId/8588880487959416832
* Revision: Document number DS16003 Rev. 24-2, December 2014
.model OC_DIODES-INCORPORATED_S1M-13-F D(IS=8.8773158846e-8 N=2.0270663279e0 RS=4.0670280809e-2)

.temp 25
Itest 0 anode DC 1.7800000000e0
Vanchor anchor 0 DC 0
Ranchor anchor 0 1G
Ddut anode 0 OC_DIODES-INCORPORATED_S1M-13-F
.op
.end
