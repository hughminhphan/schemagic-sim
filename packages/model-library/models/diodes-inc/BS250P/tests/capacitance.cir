OpenCircuit factory test: BS250P capacitance
* OpenCircuit Model Factory v0.1.0
* Original work generated from public factual specifications.
* This model is not a copy of, or adaptation from, any vendor SPICE model.
* Source: https://www.diodes.com/datasheet/download/BS250P.pdf
* Revision: DS33014 Rev. 3-2, October 2019
* Node order: drain gate source
.model OC_BS250P VDMOS(pchan VTO=-2.2500000000e+00 KP=1.0000000000e-01 THETA=0.0000000000e+00 LAMBDA=3.0000000000e-03 RD=7.7000000000e+00 RS=2.8000000000e+00 RG=1.0000000000e-04 CGS=5.9000000000e-11 CGDMAX=1.0000000000e-12 CGDMIN=1.0000000000e-12 A=1.0000000000e+00 CJO=1.0000000000e-12 IS=1.0000000000e-14 N=1.5000000000e+00 RB=2.8000000000e+00 TT=0.0000000000e+00 BV=4.5000000000e+01 IBV=1.0000000000e-04 RTHJC=0.0000000000e+00 RTHCA=0.0000000000e+00 RDS=1e9 VJ=0.8 M=0.5 FC=0.5 NBV=1 TNOM=27)

.temp 25
MI di gi 0 OC_BS250P
VDI di 0 -10
VGI gi 0 0 AC 1
.ac lin 1 1Meg 1Meg
.end
