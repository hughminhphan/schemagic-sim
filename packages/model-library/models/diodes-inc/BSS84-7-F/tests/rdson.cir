OpenCircuit factory test: BSS84-7-F RDS(on)
* OpenCircuit Model Factory v0.1.0 bulk adapter
* Original work generated from public factual specifications.
* This model is not copied or adapted from any vendor SPICE model.
* Source: https://jlcpcb.com/api/file/downloadByFileSystemAccessId/8560107418433572864
* Revision: DS30149 Rev. 26 - 2, July 2024
.model OC_DIODES-INCORPORATED_BSS84-7-F VDMOS( pchan VTO=-2.0000000000e0 KP=6.2500000000e-1 THETA=0.0000000000e0 LAMBDA=3.0000000000e-3 RD=1.7600000000e0 RS=6.4000000000e-1 RG=1.0000000000e-4 RDS=1e9 CGS=2.1800000000e-11 CGDMAX=2.8000000000e-12 CGDMIN=2.8000000000e-12 CJO=1.9000000000e-12 IS=1.0000000000e-12 N=1.5000000000e0 RB=6.4000000000e-1)

.temp 25
M1 d1 g1 0 OC_DIODES-INCORPORATED_BSS84-7-F
ID1 d1 0 DC 1.0000000000e-1
VG1 g1 0 DC -5.0000000000e0
.op
.end
