OpenCircuit factory test: MMBT3904-7-F supported-region upper-current boundary
* OpenCircuit Model Factory v0.1.0 bulk adapter
* Original work generated from public factual specifications.
* This model is not copied or adapted from any vendor SPICE model.
* Source: https://jlcpcb.com/api/file/downloadByFileSystemAccessId/8560107457311252480
* Revision: Document number DS30036 Rev. 26 - 2, November 2022
.model OC_DIODES-INCORPORATED_MMBT3904-7-F NPN(IS=1.0000000000e-14 BF=3.0000000000e2 VAF=1.0000000000e2 IKF=1.0000000000e3 RB=1.0000000000e1 RC=1.0000000000e-1 RE=5.0000000000e-2 CJE=1.0000000000e-12 CJC=1.0000000000e-12 TF=1.0000000000e-9)

.temp 25
IC 0 c DC 1.0000000000e-1
IB 0 b DC 3.3333333333e-3
Q1 c b 0 OC_DIODES-INCORPORATED_MMBT3904-7-F
.op
.end
