* OpenCircuit Model Factory v0.1.0 bulk adapter
* Original work generated from public factual specifications.
* This model is not copied or adapted from any vendor SPICE model.
* Source: https://jlcpcb.com/api/file/downloadByFileSystemAccessId/8586180471550595072
* Revision: DS31830 Rev. 4 - 2, October 2013
.model OC_DIODES-INCORPORATED_DMP2035U-7 VDMOS( pchan VTO=-7.0000000000e-1 KP=8.6956521739e1 THETA=0.0000000000e0 LAMBDA=3.0000000000e-3 RD=1.2650000000e-2 RS=4.6000000000e-3 RG=1.0000000000e-4 RDS=1e9 CGS=1.4650000000e-9 CGDMAX=1.4500000000e-10 CGDMIN=1.4500000000e-10 CJO=1.2000000000e-11 IS=1.0000000000e-12 N=1.5000000000e0 RB=4.6000000000e-3)
