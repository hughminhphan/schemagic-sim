OpenCircuit factory test: 2N7002-7-F RDS(on)
* OpenCircuit Model Factory v0.1.0 bulk adapter
* Original work generated from public factual specifications.
* This model is not copied or adapted from any vendor SPICE model.
* Source: https://jlcpcb.com/api/file/downloadByFileSystemAccessId/8757233029595316224
* Revision: DS11303 Rev. 40-2, July 2024
.model OC_DIODES-INCORPORATED_2N7002-7-F VDMOS( VTO=2.5000000000e0 KP=6.2500000000e-1 THETA=0.0000000000e0 LAMBDA=3.0000000000e-3 RD=1.7600000000e0 RS=6.4000000000e-1 RG=1.0000000000e-4 RDS=1e9 CGS=2.0000000000e-11 CGDMAX=2.0000000000e-12 CGDMIN=2.0000000000e-12 CJO=9.0000000000e-12 IS=1.0000000000e-12 N=1.5000000000e0 RB=6.4000000000e-1)

.temp 25
M1 d1 g1 0 OC_DIODES-INCORPORATED_2N7002-7-F
ID1 0 d1 DC 5.0000000000e-2
VG1 g1 0 DC 5.0000000000e0
M2 d2 g2 0 OC_DIODES-INCORPORATED_2N7002-7-F
ID2 0 d2 DC 5.0000000000e-2
VG2 g2 0 DC 5.0000000000e0
M3 d3 g3 0 OC_DIODES-INCORPORATED_2N7002-7-F
ID3 0 d3 DC 5.0000000000e-1
VG3 g3 0 DC 1.0000000000e1
M4 d4 g4 0 OC_DIODES-INCORPORATED_2N7002-7-F
ID4 0 d4 DC 5.0000000000e-1
VG4 g4 0 DC 1.0000000000e1
.op
.end
