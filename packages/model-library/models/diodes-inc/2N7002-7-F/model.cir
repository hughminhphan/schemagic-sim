* OpenCircuit Model Factory v0.1.0 bulk adapter
* Original work generated from public factual specifications.
* This model is not copied or adapted from any vendor SPICE model.
* Source: https://jlcpcb.com/api/file/downloadByFileSystemAccessId/8757233029595316224
* Revision: DS11303 Rev. 40-2, July 2024
.model OC_DIODES-INCORPORATED_2N7002-7-F VDMOS( VTO=2.5000000000e0 KP=6.2500000000e-1 THETA=0.0000000000e0 LAMBDA=3.0000000000e-3 RD=1.7600000000e0 RS=6.4000000000e-1 RG=1.0000000000e-4 RDS=1e9 CGS=2.0000000000e-11 CGDMAX=2.0000000000e-12 CGDMIN=2.0000000000e-12 CJO=9.0000000000e-12 IS=1.0000000000e-12 N=1.5000000000e0 RB=6.4000000000e-1)
