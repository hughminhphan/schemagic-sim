OpenCircuit factory test: MMBT3904T-7-F supported-region upper-current boundary
* OpenCircuit Model Factory v0.1.0 bulk adapter
* Original work generated from public factual specifications.
* This model is not copied or adapted from any vendor SPICE model.
* Source: https://jlcpcb.com/api/file/downloadByFileSystemAccessId/8588902298114805760
* Revision: DS30270 Rev. 10 - 2, April 2016
.model OC_DIODES-INCORPORATED_MMBT3904T-7-F NPN(IS=1.0000000000e-14 BF=2.5658694341e2 VAF=1.0000000000e2 IKF=4.6185541709e-2 ISE=2.5535476031e-14 NE=1.5000000000e0 NF=1.0000000000e0 RB=1.0000000000e1 RC=1.0000000000e-1 RE=5.0000000000e-2 CJE=1.0000000000e-12 CJC=1.0000000000e-12 TF=1.0000000000e-9)

.temp 25
IC 0 c DC 1.0000000000e-1
IB 0 b DC 1.3333333333e-3
Q1 c b 0 OC_DIODES-INCORPORATED_MMBT3904T-7-F
.op
.end
