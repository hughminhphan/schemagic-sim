* OpenCircuit Model Factory v0.1.0 bulk adapter
* Original work generated from public factual specifications.
* This model is not copied or adapted from any vendor SPICE model.
* Source: https://jlcpcb.com/api/file/downloadByFileSystemAccessId/8586187872558845952
* Revision: DS31447 Rev. 8 - 2, October 2013
.model OC_DIODES-INCORPORATED_DMP3098L-7 VDMOS( pchan VTO=-1.8000000000e0 KP=3.5714285714e1 THETA=0.0000000000e0 LAMBDA=3.0000000000e-3 RD=3.0800000000e-2 RS=1.1200000000e-2 RG=1.0000000000e-4 RDS=1e9 CGS=2.8700000000e-10 CGDMAX=4.9000000000e-11 CGDMIN=4.9000000000e-11 CJO=2.1000000000e-11 IS=1.0000000000e-12 N=1.5000000000e0 RB=1.1200000000e-2)
