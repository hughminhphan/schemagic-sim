OpenCircuit factory test: forward_07.cir
* OpenCircuit Model Factory v0.1.0 bulk adapter
* Original work generated from public factual specifications.
* This model is not copied or adapted from any vendor SPICE model.
* Source: https://jlcpcb.com/api/file/downloadByFileSystemAccessId/8560101323753480192
* Revision: DS30097 Rev. 28 - 2, September 2024
.model OC_DIODES-INCORPORATED_1N4148WS-7-F D(IS=6.1270493014e-9 N=1.9083239062e0 RS=1.1732449427e0)

.temp 25
Itest 0 anode DC 1.0000000000e-2
Vanchor anchor 0 DC 0
Ranchor anchor 0 1G
Ddut anode 0 OC_DIODES-INCORPORATED_1N4148WS-7-F
.op
.end
