OpenCircuit factory test: 2N7002K-7 RDS(on)
* OpenCircuit Model Factory v0.1.0 bulk adapter
* Original work generated from public factual specifications.
* This model is not copied or adapted from any vendor SPICE model.
* Source: https://jlcpcb.com/api/file/downloadByFileSystemAccessId/8586181546256027648
* Revision: DS30896 Rev. 20 - 2, July 2024
.model OC_DIODES-INCORPORATED_2N7002K-7 VDMOS( VTO=1.6000000000e0 KP=1.6666666667e0 THETA=0.0000000000e0 LAMBDA=3.0000000000e-3 RD=6.6000000000e-1 RS=2.4000000000e-1 RG=1.0000000000e-4 RDS=1e9 CGS=2.7100000000e-11 CGDMAX=2.9000000000e-12 CGDMIN=2.9000000000e-12 CJO=1.3000000000e-12 IS=1.0000000000e-12 N=1.5000000000e0 RB=2.4000000000e-1)

.temp 25
M1 d1 g1 0 OC_DIODES-INCORPORATED_2N7002K-7
ID1 0 d1 DC 5.0000000000e-1
VG1 g1 0 DC 1.0000000000e1
M2 d2 g2 0 OC_DIODES-INCORPORATED_2N7002K-7
ID2 0 d2 DC 5.0000000000e-2
VG2 g2 0 DC 5.0000000000e0
.op
.end
