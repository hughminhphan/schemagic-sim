OpenCircuit independent review hard-bound probe
* OpenCircuit Model Factory v0.1.0 bulk adapter
* Original work generated from public factual specifications.
* This model is not copied or adapted from any vendor SPICE model.
* Source: https://jlcpcb.com/api/file/downloadByFileSystemAccessId/8757890263857537024
* Revision: No revision stated
.model OC_MSKSEMI_MS50N06 VDMOS( VTO=1.6000000000e0 KP=1.3888888889e2 THETA=0.0000000000e0 LAMBDA=3.0000000000e-3 RD=7.9200000000e-3 RS=2.8800000000e-3 RG=1.0000000000e-4 RDS=1e9 CGS=2.0200000000e-9 CGDMAX=8.0000000000e-11 CGDMIN=8.0000000000e-11 CJO=8.5000000000e-11 IS=1.0000000000e-12 N=1.5000000000e0 RB=2.8800000000e-3)
.temp 25
M1 d g 0 OC_MSKSEMI_MS50N06
ID 0 d DC 1.000000000000e+1
VG g 0 DC 4.500000000000e+0
.op
.end
