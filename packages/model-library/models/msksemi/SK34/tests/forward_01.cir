OpenCircuit factory test: forward_01.cir
* OpenCircuit Model Factory v0.1.0 bulk adapter
* Original work generated from public factual specifications.
* This model is not copied or adapted from any vendor SPICE model.
* Source: https://jlcpcb.com/api/file/downloadByFileSystemAccessId/8589835590720905216
* Revision: datasheet as supplied
.model OC_MSKSEMI_SK34 D(IS=2.8023106146e-5 N=1.8000000000e0 RS=1.0000000000e-4)

.temp 2.5000000000e1
Itest 0 anode DC 3.0000000000e0
Vanchor anchor 0 DC 0
Ranchor anchor 0 1G
Ddut anode 0 OC_MSKSEMI_SK34
.op
.end
