* OpenCircuit Model Factory v0.1.0 bulk adapter
* Original work generated from public factual specifications.
* This model is not copied or adapted from any vendor SPICE model.
* Source: https://jlcpcb.com/api/file/downloadByFileSystemAccessId/8589835590720905216
* Revision: datasheet as supplied
.model OC_MSKSEMI_SK34 D(IS=2.8023106146e-5 N=1.8000000000e0 RS=1.0000000000e-4)
