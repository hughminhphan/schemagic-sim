OpenCircuit factory test: AO3401CI-MS RDS(on)
* OpenCircuit Model Factory v0.1.0 bulk adapter
* Original work generated from public factual specifications.
* This model is not copied or adapted from any vendor SPICE model.
* Source: https://jlcpcb.com/api/file/downloadByFileSystemAccessId/8555434914329436160
* Revision: not stated in supplied PDF
.model OC_MSKSEMI_AO3401CI-MS VDMOS( pchan VTO=-7.0000000000e-1 KP=3.4482758621e1 THETA=0.0000000000e0 LAMBDA=3.0000000000e-3 RD=3.1900000000e-2 RS=1.1600000000e-2 RG=1.0000000000e-4 RDS=1e9 CGS=4.4500000000e-10 CGDMAX=5.8000000000e-11 CGDMIN=5.8000000000e-11 CJO=9.0000000000e-12 IS=1.0000000000e-12 N=1.5000000000e0 RB=1.1600000000e-2)

.temp 25
M1 d1 g1 0 OC_MSKSEMI_AO3401CI-MS
ID1 d1 0 DC 3.0000000000e0
VG1 g1 0 DC -4.5000000000e0
M2 d2 g2 0 OC_MSKSEMI_AO3401CI-MS
ID2 d2 0 DC 3.0000000000e0
VG2 g2 0 DC -4.5000000000e0
M3 d3 g3 0 OC_MSKSEMI_AO3401CI-MS
ID3 d3 0 DC 2.0000000000e0
VG3 g3 0 DC -2.5000000000e0
M4 d4 g4 0 OC_MSKSEMI_AO3401CI-MS
ID4 d4 0 DC 2.0000000000e0
VG4 g4 0 DC -2.5000000000e0
.op
.end
