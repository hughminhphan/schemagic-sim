OpenCircuit factory test: forward_03.cir
* OpenCircuit Model Factory v0.1.0 bulk adapter
* Original work generated from public factual specifications.
* This model is not copied or adapted from any vendor SPICE model.
* Source: https://jlcpcb.com/api/file/downloadByFileSystemAccessId/8603058276666404864
* Revision: Not stated
.model OC_MSKSEMI_MS2A40LWS D(IS=3.7554860451e-6 N=9.3630377903e-1 RS=5.1044643335e-2)

.temp 2.5000000000e1
Itest 0 anode DC 1.0000000000e0
Vanchor anchor 0 DC 0
Ranchor anchor 0 1G
Ddut anode 0 OC_MSKSEMI_MS2A40LWS
.op
.end
