* OpenCircuit Model Factory v0.1.0 bulk adapter
* Original work generated from public factual specifications.
* This model is not copied or adapted from any vendor SPICE model.
* Source: https://jlcpcb.com/api/file/downloadByFileSystemAccessId/8603058276666404864
* Revision: Not stated
.model OC_MSKSEMI_MS2A40LWS D(IS=3.7554860451e-6 N=9.3630377903e-1 RS=5.1044643335e-2)
