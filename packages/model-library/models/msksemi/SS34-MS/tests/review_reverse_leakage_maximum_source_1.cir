OpenCircuit independent review hard-bound probe
* OpenCircuit Model Factory v0.1.0 bulk adapter
* Original work generated from public factual specifications.
* This model is not copied or adapted from any vendor SPICE model.
* Source: https://jlcpcb.com/api/file/downloadByFileSystemAccessId/8588907327055806464
* Revision: Not stated in supplied PDF
.model OC_MSKSEMI_SS34-MS D(IS=1.8240110209e-8 N=1.1000000000e0 RS=1.0000000000e-4)
.temp 25
Vreverse cathode 0 DC 4.000000000000e+01
Ddut 0 cathode OC_MSKSEMI_SS34-MS
.op
.end
