OpenCircuit factory test: 2N7002KX RDS(on)
* OpenCircuit Model Factory v0.1.0 bulk adapter
* Original work generated from public factual specifications.
* This model is not copied or adapted from any vendor SPICE model.
* Source: https://jlcpcb.com/api/file/downloadByFileSystemAccessId/8590240027352596480
* Revision: Revision B5
.model OC_SHENZHEN-JINGYANG_2N7002KX VDMOS( VTO=2.5000000000e0 KP=1.0000000000e0 THETA=0.0000000000e0 LAMBDA=3.0000000000e-3 RD=1.1000000000e0 RS=4.0000000000e-1 RG=1.0000000000e-4 RDS=1e9 CGS=1.7000000000e-11 CGDMAX=4.0000000000e-12 CGDMIN=4.0000000000e-12 CJO=7.0000000000e-12 IS=1.0000000000e-12 N=1.5000000000e0 RB=4.0000000000e-1)

.temp 25
M1 d1 g1 0 OC_SHENZHEN-JINGYANG_2N7002KX
ID1 0 d1 DC 3.0000000000e-1
VG1 g1 0 DC 1.0000000000e1
M2 d2 g2 0 OC_SHENZHEN-JINGYANG_2N7002KX
ID2 0 d2 DC 3.0000000000e-1
VG2 g2 0 DC 1.0000000000e1
M3 d3 g3 0 OC_SHENZHEN-JINGYANG_2N7002KX
ID3 0 d3 DC 3.0000000000e-1
VG3 g3 0 DC 5.0000000000e0
M4 d4 g4 0 OC_SHENZHEN-JINGYANG_2N7002KX
ID4 0 d4 DC 3.0000000000e-1
VG4 g4 0 DC 5.0000000000e0
.op
.end
