OpenCircuit factory test: CR4N65A4K RDS(on)
* OpenCircuit Model Factory v0.1.0 bulk adapter
* Original work generated from public factual specifications.
* This model is not copied or adapted from any vendor SPICE model.
* Source: https://jlcpcb.com/api/file/downloadByFileSystemAccessId/8588904101022715904
* Revision: 2020V01
.model OC_CRMICRO_CR4N65A4K VDMOS( VTO=4.0000000000e0 KP=8.3333333333e-1 THETA=0.0000000000e0 LAMBDA=3.0000000000e-3 RD=1.3200000000e0 RS=4.8000000000e-1 RG=1.0000000000e-4 RDS=1e9 CGS=5.6160000000e-10 CGDMAX=2.4000000000e-12 CGDMIN=2.4000000000e-12 CJO=3.8600000000e-11 IS=1.0000000000e-12 N=1.5000000000e0 RB=4.8000000000e-1)

.temp 25
M1 d1 g1 0 OC_CRMICRO_CR4N65A4K
ID1 0 d1 DC 2.0000000000e0
VG1 g1 0 DC 1.0000000000e1
.op
.end
