OpenCircuit factory test: CRSS052N08N RDS(on)
* OpenCircuit Model Factory v0.1.0 bulk adapter
* Original work generated from public factual specifications.
* This model is not copied or adapted from any vendor SPICE model.
* Source: https://jlcpcb.com/api/file/downloadByFileSystemAccessId/8588885207272972288
* Revision: 3.0 (2019-05-31)
.model OC_CRMICRO_CRSS052N08N VDMOS( VTO=3.0000000000e0 KP=4.6511627907e2 THETA=0.0000000000e0 LAMBDA=3.0000000000e-3 RD=2.3650000000e-3 RS=8.6000000000e-4 RG=1.0000000000e-4 RDS=1e9 CGS=3.0600000000e-9 CGDMAX=2.6000000000e-11 CGDMIN=2.6000000000e-11 CJO=1.0310000000e-9 IS=1.0000000000e-12 N=1.5000000000e0 RB=8.6000000000e-4)

.temp 25
M1 d1 g1 0 OC_CRMICRO_CRSS052N08N
ID1 0 d1 DC 5.0000000000e1
VG1 g1 0 DC 1.0000000000e1
.op
.end
