* OpenCircuit Model Factory v0.1.0 bulk adapter
* Original work generated from public factual specifications.
* This model is not copied or adapted from any vendor SPICE model.
* Source: https://jlcpcb.com/api/file/downloadByFileSystemAccessId/8588917733920002049
* Revision: Rev.3.0, 20-Feb-20
.model OC_YANGZHOU-YANGJIE-ELEC-TECH_YJQ40G10A VDMOS( VTO=1.8000000000e0 KP=1.0810810811e2 THETA=0.0000000000e0 LAMBDA=3.0000000000e-3 RD=1.0175000000e-2 RS=3.7000000000e-3 RG=1.0000000000e-4 RDS=1e9 CGS=1.0330000000e-9 CGDMAX=1.8000000000e-11 CGDMIN=1.8000000000e-11 CJO=3.8100000000e-10 IS=1.0000000000e-12 N=1.5000000000e0 RB=3.7000000000e-3)
