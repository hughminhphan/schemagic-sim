* OpenCircuit Model Factory v0.1.0 bulk adapter
* Original work generated from public factual specifications.
* This model is not copied or adapted from any vendor SPICE model.
* Source: https://jlcpcb.com/api/file/downloadByFileSystemAccessId/8588918623443935232
* Revision: S-S036 Rev. 2.4, 23-Apr-19
.model OC_YANGZHOU-YANGJIE-ELEC-TECH_G1M D(IS=9.0906982619e-11 N=1.8000000000e0 RS=1.0000000000e-4)
