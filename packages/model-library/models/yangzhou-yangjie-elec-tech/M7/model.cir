* OpenCircuit Model Factory v0.1.0 bulk adapter
* Original work generated from public factual specifications.
* This model is not copied or adapted from any vendor SPICE model.
* Source: https://jlcpcb.com/api/file/downloadByFileSystemAccessId/8588905132926898176
* Revision: Rev.1.3, 08-Nov-18
.model OC_YANGZHOU-YANGJIE-ELEC-TECH_M7 D(IS=4.6779138942e-8 N=2.1085035445e0 RS=2.7840086643e-2)
