OpenCircuit factory test: forward_01.cir
* OpenCircuit Model Factory v0.1.0 bulk adapter
* Original work generated from public factual specifications.
* This model is not copied or adapted from any vendor SPICE model.
* Source: https://jlcpcb.com/api/file/downloadByFileSystemAccessId/8588905132926898176
* Revision: Rev.1.3, 08-Nov-18
.model OC_YANGZHOU-YANGJIE-ELEC-TECH_M7 D(IS=4.6779138942e-8 N=2.1085035445e0 RS=2.7840086643e-2)

.temp 25
Itest 0 anode DC 5.0000000000e-2
Vanchor anchor 0 DC 0
Ranchor anchor 0 1G
Ddut anode 0 OC_YANGZHOU-YANGJIE-ELEC-TECH_M7
.op
.end
