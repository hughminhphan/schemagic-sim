OpenCircuit factory test: RC3415P RDS(on)
* OpenCircuit Model Factory v0.1.0 bulk adapter
* Original work generated from public factual specifications.
* This model is not copied or adapted from any vendor SPICE model.
* Source: https://jlcpcb.com/api/file/downloadByFileSystemAccessId/8589838068573372416
* Revision: Not stated in the supplied datasheet
.model OC_REALCHIP_RC3415P VDMOS( pchan VTO=-1.0000000000e0 KP=5.5555555556e1 THETA=0.0000000000e0 LAMBDA=3.0000000000e-3 RD=1.9800000000e-2 RS=7.2000000000e-3 RG=1.0000000000e-4 RDS=1e9 CGS=1.2900000000e-9 CGDMAX=1.6000000000e-10 CGDMIN=1.6000000000e-10 CJO=4.5000000000e-11 IS=1.0000000000e-12 N=1.5000000000e0 RB=7.2000000000e-3)

.temp 25
M1 d1 g1 0 OC_REALCHIP_RC3415P
ID1 d1 0 DC 4.0000000000e0
VG1 g1 0 DC -4.5000000000e0
.op
.end
