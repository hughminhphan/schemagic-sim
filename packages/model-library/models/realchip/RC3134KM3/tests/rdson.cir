OpenCircuit factory test: RC3134KM3 RDS(on)
* OpenCircuit Model Factory v0.1.0 bulk adapter
* Original work generated from public factual specifications.
* This model is not copied or adapted from any vendor SPICE model.
* Source: https://jlcpcb.com/api/file/downloadByFileSystemAccessId/8590269426034909184
* Revision: not stated (no revision code or date printed in document)
.model OC_REALCHIP_RC3134KM3 VDMOS( VTO=1.0000000000e0 KP=1.0526315789e1 THETA=0.0000000000e0 LAMBDA=3.0000000000e-3 RD=1.0450000000e-1 RS=3.8000000000e-2 RG=1.0000000000e-4 RDS=1e9 CGS=3.7000000000e-11 CGDMAX=6.0000000000e-12 CGDMIN=6.0000000000e-12 CJO=3.0000000000e-12 IS=1.0000000000e-12 N=1.5000000000e0 RB=3.8000000000e-2)

.temp 25
M1 d1 g1 0 OC_REALCHIP_RC3134KM3
ID1 0 d1 DC 5.5000000000e-1
VG1 g1 0 DC 4.5000000000e0
.op
.end
