OpenCircuit factory test: TPM7002DFN3 RDS(on)
* OpenCircuit Model Factory v0.1.0 bulk adapter
* Original work generated from public factual specifications.
* This model is not copied or adapted from any vendor SPICE model.
* Source: https://jlcpcb.com/api/file/downloadByFileSystemAccessId/8588912342117990400
* Revision: Revision not stated; document created 2018-07-30
.model OC_TECH-PUBLIC_TPM7002DFN3 VDMOS( VTO=1.5000000000e0 KP=8.8888888889e-1 THETA=0.0000000000e0 LAMBDA=3.0000000000e-3 RD=1.2375000000e0 RS=4.5000000000e-1 RG=1.0000000000e-4 RDS=1e9 CGS=1.0500000000e-11 CGDMAX=5.5000000000e-12 CGDMIN=5.5000000000e-12 CJO=4.5000000000e-12 IS=1.0000000000e-12 N=1.5000000000e0 RB=4.5000000000e-1)

.temp 25
M1 d1 g1 0 OC_TECH-PUBLIC_TPM7002DFN3
ID1 0 d1 DC 3.0000000000e-1
VG1 g1 0 DC 1.0000000000e1
.op
.end
