* OpenCircuit Model Factory v0.1.0 bulk adapter
* Original work generated from public factual specifications.
* This model is not copied or adapted from any vendor SPICE model.
* Source: https://jlcpcb.com/api/file/downloadByFileSystemAccessId/8603400131584667648
* Revision: Not stated in datasheet
.model OC_TECH-PUBLIC_TPNSR05F40NXT5G D(IS=1.0364420176e-7 N=1.1000000000e0 RS=1.0000000000e-4)
