OpenCircuit independent review hard-bound probe
* OpenCircuit Model Factory v0.1.0 bulk adapter
* Original work generated from public factual specifications.
* This model is not copied or adapted from any vendor SPICE model.
* Source: https://jlcpcb.com/api/file/downloadByFileSystemAccessId/8589839419256971264
* Revision: Revision not stated
.model OC_TECH-PUBLIC_PMV48XP VDMOS( pchan VTO=-7.0000000000e-1 KP=4.2735042735e1 THETA=0.0000000000e0 LAMBDA=3.0000000000e-3 RD=2.5740000000e-2 RS=9.3600000000e-3 RG=1.0000000000e-4 RDS=1e9 CGS=5.5000000000e-10 CGDMAX=1.9000000000e-10 CGDMIN=1.9000000000e-10 CJO=1.0000000000e-10 IS=1.0000000000e-12 N=1.5000000000e0 RB=9.3600000000e-3)
.temp 25
M1 d g 0 OC_TECH-PUBLIC_PMV48XP
ID d 0 DC 3.000000000000e+0
VG g 0 DC -2.500000000000e+0
.op
.end
