OpenCircuit factory test: forward_01.cir
* OpenCircuit Model Factory v0.1.0 bulk adapter
* Original work generated from public factual specifications.
* This model is not copied or adapted from any vendor SPICE model.
* Source: https://jlcpcb.com/api/file/downloadByFileSystemAccessId/8588915348216799232
* Revision: revision not stated in source
.model OC_TECH-PUBLIC_RB520S-30 D(IS=2.1654990212e-10 N=1.1000000000e0 RS=1.0000000000e-4)

.temp 2.5000000000e1
Itest 0 anode DC 2.0000000000e-1
Vanchor anchor 0 DC 0
Ranchor anchor 0 1G
Ddut anode 0 OC_TECH-PUBLIC_RB520S-30
.op
.end
