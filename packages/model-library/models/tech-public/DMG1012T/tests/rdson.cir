OpenCircuit factory test: DMG1012T RDS(on)
* OpenCircuit Model Factory v0.1.0 bulk adapter
* Original work generated from public factual specifications.
* This model is not copied or adapted from any vendor SPICE model.
* Source: https://jlcpcb.com/api/file/downloadByFileSystemAccessId/8588944021167755264
* Revision: Not stated in supplied datasheet
.model OC_TECH-PUBLIC_DMG1012T VDMOS( VTO=7.5000000000e-1 KP=1.1111111111e1 THETA=0.0000000000e0 LAMBDA=3.0000000000e-3 RD=9.9000000000e-2 RS=3.6000000000e-2 RG=1.0000000000e-4 RDS=1e9 CGS=1.0500000000e-10 CGDMAX=1.5000000000e-11 CGDMIN=1.5000000000e-11 CJO=5.0000000000e-12 IS=1.0000000000e-12 N=1.5000000000e0 RB=3.6000000000e-2)

.temp 25
M1 d1 g1 0 OC_TECH-PUBLIC_DMG1012T
ID1 0 d1 DC 5.5000000000e-1
VG1 g1 0 DC 4.5000000000e0
M2 d2 g2 0 OC_TECH-PUBLIC_DMG1012T
ID2 0 d2 DC 5.5000000000e-1
VG2 g2 0 DC 4.5000000000e0
M3 d3 g3 0 OC_TECH-PUBLIC_DMG1012T
ID3 0 d3 DC 4.5000000000e-1
VG3 g3 0 DC 2.5000000000e0
M4 d4 g4 0 OC_TECH-PUBLIC_DMG1012T
ID4 0 d4 DC 4.5000000000e-1
VG4 g4 0 DC 2.5000000000e0
.op
.end
