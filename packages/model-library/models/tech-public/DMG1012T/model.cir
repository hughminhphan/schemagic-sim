* OpenCircuit Model Factory v0.1.0 bulk adapter
* Original work generated from public factual specifications.
* This model is not copied or adapted from any vendor SPICE model.
* Source: https://jlcpcb.com/api/file/downloadByFileSystemAccessId/8588944021167755264
* Revision: Not stated in supplied datasheet
.model OC_TECH-PUBLIC_DMG1012T VDMOS( VTO=7.5000000000e-1 KP=1.1111111111e1 THETA=0.0000000000e0 LAMBDA=3.0000000000e-3 RD=9.9000000000e-2 RS=3.6000000000e-2 RG=1.0000000000e-4 RDS=1e9 CGS=1.0500000000e-10 CGDMAX=1.5000000000e-11 CGDMIN=1.5000000000e-11 CJO=5.0000000000e-12 IS=1.0000000000e-12 N=1.5000000000e0 RB=3.6000000000e-2)
