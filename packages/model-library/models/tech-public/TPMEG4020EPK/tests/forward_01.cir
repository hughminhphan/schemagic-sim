OpenCircuit factory test: forward_01.cir
* OpenCircuit Model Factory v0.1.0 bulk adapter
* Original work generated from public factual specifications.
* This model is not copied or adapted from any vendor SPICE model.
* Source: https://jlcpcb.com/api/file/downloadByFileSystemAccessId/8555428538261606400
* Revision: Not stated
.model OC_TECH-PUBLIC_TPMEG4020EPK D(IS=9.4070089859e-8 N=1.1000000000e0 RS=1.0000000000e-4)

.temp 2.5000000000e1
Itest 0 anode DC 1.0000000000e0
Vanchor anchor 0 DC 0
Ranchor anchor 0 1G
Ddut anode 0 OC_TECH-PUBLIC_TPMEG4020EPK
.op
.end
