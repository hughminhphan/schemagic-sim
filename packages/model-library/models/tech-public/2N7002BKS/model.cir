* OpenCircuit Model Factory v0.1.0 bulk adapter
* Original work generated from public factual specifications.
* This model is not copied or adapted from any vendor SPICE model.
* Source: https://jlcpcb.com/api/file/downloadByFileSystemAccessId/8588947557644423168
* Revision: Revision not stated
.model OC_TECH-PUBLIC_2N7002BKS VDMOS( VTO=1.6000000000e0 KP=8.8888888889e-1 THETA=0.0000000000e0 LAMBDA=3.0000000000e-3 RD=1.2375000000e0 RS=4.5000000000e-1 RG=1.0000000000e-4 RDS=1e9 CGS=2.5000000000e-11 CGDMAX=2.0000000000e-12 CGDMIN=2.0000000000e-12 CJO=1.6000000000e-11 IS=1.0000000000e-12 N=1.5000000000e0 RB=4.5000000000e-1)
