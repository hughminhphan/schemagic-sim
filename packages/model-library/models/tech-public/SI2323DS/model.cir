* OpenCircuit Model Factory v0.1.0 bulk adapter
* Original work generated from public factual specifications.
* This model is not copied or adapted from any vendor SPICE model.
* Source: https://jlcpcb.com/api/file/downloadByFileSystemAccessId/8590442898639921152
* Revision: 1
.model OC_TECH-PUBLIC_SI2323DS VDMOS( pchan VTO=-7.0000000000e-1 KP=5.1282051282e1 THETA=0.0000000000e0 LAMBDA=3.0000000000e-3 RD=2.1450000000e-2 RS=7.8000000000e-3 RG=1.0000000000e-4 RDS=1e9 CGS=5.5000000000e-10 CGDMAX=1.9000000000e-10 CGDMIN=1.9000000000e-10 CJO=1.0000000000e-10 IS=1.0000000000e-12 N=1.5000000000e0 RB=7.8000000000e-3)
