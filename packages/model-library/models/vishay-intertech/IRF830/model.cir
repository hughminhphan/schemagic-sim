* OpenCircuit Model Factory v0.1.0 bulk adapter
* Original work generated from public factual specifications.
* This model is not copied or adapted from any vendor SPICE model.
* Source: https://jlcpcb.com/api/file/downloadByFileSystemAccessId/8588887159516368896
* Revision: S11-0506-Rev. B, 21-Mar-11
.model OC_VISHAY-INTERTECH_IRF830PBF VDMOS( VTO=4.0000000000e0 KP=1.4814814815e0 THETA=0.0000000000e0 LAMBDA=3.0000000000e-3 RD=7.4250000000e-1 RS=2.7000000000e-1 RG=1.0000000000e-4 RDS=1e9 CGS=5.4200000000e-10 CGDMAX=6.8000000000e-11 CGDMIN=6.8000000000e-11 CJO=9.2000000000e-11 IS=1.0000000000e-12 N=1.5000000000e0 RB=2.7000000000e-1)
