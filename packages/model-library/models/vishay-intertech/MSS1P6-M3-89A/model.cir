* OpenCircuit Model Factory v0.1.0 bulk adapter
* Original work generated from public factual specifications.
* This model is not copied or adapted from any vendor SPICE model.
* Source: https://jlcpcb.com/api/file/downloadByFileSystemAccessId/8589834567906320384
* Revision: revision not stated in source
.model OC_VISHAY-INTERTECH_MSS1P6-M3-89A D(IS=3.5728254307e-7 N=1.1000000000e0 RS=1.0000000000e-4)
