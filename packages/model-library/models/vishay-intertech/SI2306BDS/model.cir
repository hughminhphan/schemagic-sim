* OpenCircuit Model Factory v0.1.0 bulk adapter
* Original work generated from public factual specifications.
* This model is not copied or adapted from any vendor SPICE model.
* Source: https://jlcpcb.com/api/file/downloadByFileSystemAccessId/8588916770313158656
* Revision: S-80642-Rev. B, 24-Mar-08
.model OC_VISHAY-INTERTECH_SI2306BDS-T1-E3 VDMOS( VTO=3.0000000000e0 KP=5.2631578947e1 THETA=0.0000000000e0 LAMBDA=3.0000000000e-3 RD=2.0900000000e-2 RS=7.6000000000e-3 RG=1.0000000000e-4 RDS=1e9 CGS=2.7600000000e-10 CGDMAX=2.9000000000e-11 CGDMIN=2.9000000000e-11 CJO=3.6000000000e-11 IS=1.0000000000e-12 N=1.5000000000e0 RB=7.6000000000e-3)
