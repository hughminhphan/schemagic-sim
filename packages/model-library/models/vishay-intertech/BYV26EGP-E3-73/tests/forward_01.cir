OpenCircuit factory test: forward_01.cir
* OpenCircuit Model Factory v0.1.0 bulk adapter
* Original work generated from public factual specifications.
* This model is not copied or adapted from any vendor SPICE model.
* Source: https://jlcpcb.com/api/file/downloadByFileSystemAccessId/8588887001718534144
* Revision: revision not stated in source
.model OC_VISHAY-INTERTECH_BYV26EGP-E3-73 D(IS=1.6063731465e-23 N=1.8000000000e0 RS=1.0000000000e-4)

.temp 2.5000000000e1
Itest 0 anode DC 1.0000000000e0
Vanchor anchor 0 DC 0
Ranchor anchor 0 1G
Ddut anode 0 OC_VISHAY-INTERTECH_BYV26EGP-E3-73
.op
.end
