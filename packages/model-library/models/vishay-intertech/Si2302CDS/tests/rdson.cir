OpenCircuit factory test: Si2302CDS-T1-GE3 RDS(on)
* OpenCircuit Model Factory v0.1.0 bulk adapter
* Original work generated from public factual specifications.
* This model is not copied or adapted from any vendor SPICE model.
* Source: https://jlcpcb.com/api/file/downloadByFileSystemAccessId/8586172403622301696
* Revision: S-81007-Rev. A, 05-May-08
.model OC_VISHAY-INTERTECH_SI2302CDS-T1-GE3 VDMOS( VTO=8.5000000000e-1 KP=4.4444444444e1 THETA=0.0000000000e0 LAMBDA=3.0000000000e-3 RD=2.4750000000e-2 RS=9.0000000000e-3 RG=1.0000000000e-4 RDS=1e9 CGS=3.1500000000e-10 CGDMAX=5.0000000000e-12 CGDMIN=5.0000000000e-12 CJO=1.9500000000e-10 IS=1.0000000000e-12 N=1.5000000000e0 RB=9.0000000000e-3)

.temp 25
M1 d1 g1 0 OC_VISHAY-INTERTECH_SI2302CDS-T1-GE3
ID1 0 d1 DC 3.6000000000e0
VG1 g1 0 DC 4.5000000000e0
.op
.end
