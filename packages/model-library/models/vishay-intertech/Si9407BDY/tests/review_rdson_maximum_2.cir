OpenCircuit independent review hard-bound probe
* OpenCircuit Model Factory v0.1.0 bulk adapter
* Original work generated from public factual specifications.
* This model is not copied or adapted from any vendor SPICE model.
* Source: https://jlcpcb.com/api/file/downloadByFileSystemAccessId/8588879925147545600
* Revision: S09-0704-Rev. B, 27-Apr-09
.model OC_VISHAY-INTERTECH_SI9407BDY-T1-GE3 VDMOS( pchan VTO=-3.0000000000e0 KP=2.0000000000e1 THETA=0.0000000000e0 LAMBDA=3.0000000000e-3 RD=5.5000000000e-2 RS=2.0000000000e-2 RG=1.0000000000e-4 RDS=1e9 CGS=5.5000000000e-10 CGDMAX=5.0000000000e-11 CGDMIN=5.0000000000e-11 CJO=2.0000000000e-11 IS=1.0000000000e-12 N=1.5000000000e0 RB=2.0000000000e-2)
.temp 25
M1 d g 0 OC_VISHAY-INTERTECH_SI9407BDY-T1-GE3
ID d 0 DC 2.900000000000e+0
VG g 0 DC -4.500000000000e+0
.op
.end
