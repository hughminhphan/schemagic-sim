OpenCircuit factory test: IRFL9014TRPBF RDS(on)
* OpenCircuit Model Factory v0.1.0 bulk adapter
* Original work generated from public factual specifications.
* This model is not copied or adapted from any vendor SPICE model.
* Source: https://jlcpcb.com/api/file/downloadByFileSystemAccessId/8579711401449361408
* Revision: S14-1686-Rev. F, 18-Aug-14
.model OC_VISHAY-INTERTECH_IRFL9014TRPBF VDMOS( pchan VTO=-4.0000000000e0 KP=4.4444444444e0 THETA=0.0000000000e0 LAMBDA=3.0000000000e-3 RD=2.4750000000e-1 RS=9.0000000000e-2 RG=1.0000000000e-4 RDS=1e9 CGS=2.3900000000e-10 CGDMAX=3.1000000000e-11 CGDMIN=3.1000000000e-11 CJO=1.3900000000e-10 IS=1.0000000000e-12 N=1.5000000000e0 RB=9.0000000000e-2)

.temp 25
M1 d1 g1 0 OC_VISHAY-INTERTECH_IRFL9014TRPBF
ID1 d1 0 DC 1.1000000000e0
VG1 g1 0 DC -1.0000000000e1
.op
.end
