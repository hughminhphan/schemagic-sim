OpenCircuit factory test: forward_01.cir
* OpenCircuit Model Factory v0.1.0 bulk adapter
* Original work generated from public factual specifications.
* This model is not copied or adapted from any vendor SPICE model.
* Source: https://jlcpcb.com/api/file/downloadByFileSystemAccessId/8588935399255654400
* Revision: 02-Aug-13
.model OC_VISHAY-INTERTECH_SS5P10-M3-86A D(IS=3.6887373367e-13 N=1.1000000000e0 RS=1.0000000000e-4)

.temp 2.5000000000e1
Itest 0 anode DC 5.0000000000e0
Vanchor anchor 0 DC 0
Ranchor anchor 0 1G
Ddut anode 0 OC_VISHAY-INTERTECH_SS5P10-M3-86A
.op
.end
