OpenCircuit independent review hard-bound probe
* OpenCircuit Model Factory v0.1.0 bulk adapter
* Original work generated from public factual specifications.
* This model is not copied or adapted from any vendor SPICE model.
* Source: https://jlcpcb.com/api/file/downloadByFileSystemAccessId/8586177185753272320
* Revision: S10-0720-Rev. C, 29-Mar-10
.model OC_VISHAY-INTERTECH_SI2305CDS-T1-GE3 VDMOS( pchan VTO=-1.0000000000e0 KP=7.1428571429e1 THETA=0.0000000000e0 LAMBDA=3.0000000000e-3 RD=1.5400000000e-2 RS=5.6000000000e-3 RG=1.0000000000e-4 RDS=1e9 CGS=6.6000000000e-10 CGDMAX=3.0000000000e-10 CGDMIN=3.0000000000e-10 CJO=3.0000000000e-11 IS=1.0000000000e-12 N=1.5000000000e0 RB=5.6000000000e-3)
.temp 25
M1 d g 0 OC_VISHAY-INTERTECH_SI2305CDS-T1-GE3
ID d 0 DC 3.800000000000e+0
VG g 0 DC -2.500000000000e+0
.op
.end
