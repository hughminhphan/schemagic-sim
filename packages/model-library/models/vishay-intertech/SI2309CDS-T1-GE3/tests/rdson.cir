OpenCircuit factory test: SI2309CDS-T1-GE3 RDS(on)
* OpenCircuit Model Factory v0.1.0 bulk adapter
* Original work generated from public factual specifications.
* This model is not copied or adapted from any vendor SPICE model.
* Source: https://jlcpcb.com/api/file/downloadByFileSystemAccessId/8586172434227056640
* Revision: S-82584-Rev. A, 27-Oct-08
.model OC_VISHAY-INTERTECH_SI2309CDS-T1-GE3 VDMOS( pchan VTO=-3.0000000000e0 KP=7.0175438596e0 THETA=0.0000000000e0 LAMBDA=3.0000000000e-3 RD=1.5675000000e-1 RS=5.7000000000e-2 RG=1.0000000000e-4 RDS=1e9 CGS=1.9000000000e-10 CGDMAX=2.0000000000e-11 CGDMIN=2.0000000000e-11 CJO=8.0000000000e-12 IS=1.0000000000e-12 N=1.5000000000e0 RB=5.7000000000e-2)

.temp 25
M1 d1 g1 0 OC_VISHAY-INTERTECH_SI2309CDS-T1-GE3
ID1 d1 0 DC 1.2500000000e0
VG1 g1 0 DC -1.0000000000e1
M2 d2 g2 0 OC_VISHAY-INTERTECH_SI2309CDS-T1-GE3
ID2 d2 0 DC 1.2500000000e0
VG2 g2 0 DC -1.0000000000e1
M3 d3 g3 0 OC_VISHAY-INTERTECH_SI2309CDS-T1-GE3
ID3 d3 0 DC 1.0000000000e0
VG3 g3 0 DC -4.5000000000e0
M4 d4 g4 0 OC_VISHAY-INTERTECH_SI2309CDS-T1-GE3
ID4 d4 0 DC 1.0000000000e0
VG4 g4 0 DC -4.5000000000e0
.op
.end
