* OpenCircuit Model Factory v0.1.0 bulk adapter
* Original work generated from public factual specifications.
* This model is not copied or adapted from any vendor SPICE model.
* Source: https://jlcpcb.com/api/file/downloadByFileSystemAccessId/8588936142682644480
* Revision: Revision: 31-Jul-2018, Document Number: 88711
.model OC_VISHAY-INTERTECH_S1G-E3-61T D(IS=2.1654227750e-7 N=2.4027124173e0 RS=3.2877122526e-2)
