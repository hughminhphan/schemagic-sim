OpenCircuit factory test: forward_07.cir
* OpenCircuit Model Factory v0.1.0 bulk adapter
* Original work generated from public factual specifications.
* This model is not copied or adapted from any vendor SPICE model.
* Source: https://jlcpcb.com/api/file/downloadByFileSystemAccessId/8588936142682644480
* Revision: Revision: 31-Jul-2018, Document Number: 88711
.model OC_VISHAY-INTERTECH_S1G-E3-61T D(IS=2.1654227750e-7 N=2.4027124173e0 RS=3.2877122526e-2)

.temp 2.5000000000e1
Itest 0 anode PULSE(0 1.0000000000e0 3.0000000000e-4 3.0000000000e-7 3.0000000000e-7 3.0000000000e-4 3.0000000000e-2)
Vanchor anchor 0 DC 0
Ranchor anchor 0 1G
Ddut anode 0 OC_VISHAY-INTERTECH_S1G-E3-61T
.tran 7.5000000000e-6 5.2530000000e-4
.end
