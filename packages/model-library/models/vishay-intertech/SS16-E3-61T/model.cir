* OpenCircuit Model Factory v0.1.0 bulk adapter
* Original work generated from public factual specifications.
* This model is not copied or adapted from any vendor SPICE model.
* Source: https://jlcpcb.com/api/file/downloadByFileSystemAccessId/8588905040627585024
* Revision: Revision: 21-Jul-17, Document Number: 88746
.model OC_VISHAY-INTERTECH_SS16-E3-61T D(IS=6.3070166706e-12 N=1.1000000000e0 RS=1.0000000000e-4)
