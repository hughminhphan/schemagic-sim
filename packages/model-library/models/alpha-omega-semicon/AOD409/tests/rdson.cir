OpenCircuit factory test: AOD409 RDS(on)
* OpenCircuit Model Factory v0.1.0 bulk adapter
* Original work generated from public factual specifications.
* This model is not copied or adapted from any vendor SPICE model.
* Source: https://jlcpcb.com/api/file/downloadByFileSystemAccessId/8586202642868031488
* Revision: Rev 5: Jan 2011
.model OC_ALPHA-OMEGA-SEMICON_AOD409 VDMOS( pchan VTO=-1.9000000000e0 KP=6.2500000000e1 THETA=0.0000000000e0 LAMBDA=3.0000000000e-3 RD=1.7600000000e-2 RS=6.4000000000e-3 RG=1.0000000000e-4 RDS=1e9 CGS=3.4470000000e-9 CGDMAX=1.5300000000e-10 CGDMIN=1.5300000000e-10 CJO=8.8000000000e-11 IS=1.0000000000e-12 N=1.5000000000e0 RB=6.4000000000e-3)

.temp 25
M1 d1 g1 0 OC_ALPHA-OMEGA-SEMICON_AOD409
ID1 d1 0 DC 2.0000000000e1
VG1 g1 0 DC -1.0000000000e1
M2 d2 g2 0 OC_ALPHA-OMEGA-SEMICON_AOD409
ID2 d2 0 DC 2.0000000000e1
VG2 g2 0 DC -1.0000000000e1
M3 d3 g3 0 OC_ALPHA-OMEGA-SEMICON_AOD409
ID3 d3 0 DC 2.0000000000e1
VG3 g3 0 DC -4.5000000000e0
M4 d4 g4 0 OC_ALPHA-OMEGA-SEMICON_AOD409
ID4 d4 0 DC 2.0000000000e1
VG4 g4 0 DC -4.5000000000e0
.op
.end
