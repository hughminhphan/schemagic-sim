* OpenCircuit Model Factory v0.1.0 bulk adapter
* Original work generated from public factual specifications.
* This model is not copied or adapted from any vendor SPICE model.
* Source: https://jlcpcb.com/api/file/downloadByFileSystemAccessId/8588885112184717312
* Revision: Rev.1.0: November 2019
.model OC_ALPHA-OMEGA-SEMICON_AO4407C VDMOS( pchan VTO=-1.8000000000e0 KP=2.1052631579e2 THETA=0.0000000000e0 LAMBDA=3.0000000000e-3 RD=5.2250000000e-3 RS=1.9000000000e-3 RG=1.0000000000e-4 RDS=1e9 CGS=1.7500000000e-9 CGDMAX=3.0000000000e-10 CGDMIN=3.0000000000e-10 CJO=3.0000000000e-11 IS=1.0000000000e-12 N=1.5000000000e0 RB=1.9000000000e-3)
