* OpenCircuit Model Factory v0.1.0 bulk adapter
* Original work generated from public factual specifications.
* This model is not copied or adapted from any vendor SPICE model.
* Source: https://jlcpcb.com/api/file/downloadByFileSystemAccessId/8586179461759053824
* Revision: Rev 10, Jan. 2011
.model OC_ALPHA-OMEGA-SEMICON_AO3403 VDMOS( pchan VTO=-1.0000000000e0 KP=2.2727272727e1 THETA=0.0000000000e0 LAMBDA=3.0000000000e-3 RD=4.8400000000e-2 RS=1.7600000000e-2 RG=1.0000000000e-4 RDS=1e9 CGS=1.0000000000e-15 CGDMAX=2.0000000000e-8 CGDMIN=2.0000000000e-8 CJO=1.7000000000e-8 IS=1.0000000000e-12 N=1.5000000000e0 RB=1.7600000000e-2)
