* OpenCircuit Model Factory v0.1.0 bulk adapter
* Original work generated from public factual specifications.
* This model is not copied or adapted from any vendor SPICE model.
* Source: https://jlcpcb.com/api/file/downloadByFileSystemAccessId/8588911565043077120
* Revision: 2.0
.model OC_ALPHA-OMEGA-SEMICON_AON7264E VDMOS( VTO=1.8000000000e0 KP=2.5974025974e2 THETA=0.0000000000e0 LAMBDA=3.0000000000e-3 RD=4.2350000000e-3 RS=1.5400000000e-3 RG=1.0000000000e-4 RDS=1e9 CGS=1.0720000000e-9 CGDMAX=2.8000000000e-11 CGDMIN=2.8000000000e-11 CJO=2.7200000000e-10 IS=1.0000000000e-12 N=1.5000000000e0 RB=1.5400000000e-3)
