* OpenCircuit Model Factory v0.1.0 bulk adapter
* Original work generated from public factual specifications.
* This model is not copied or adapted from any vendor SPICE model.
* Source: https://jlcpcb.com/api/file/downloadByFileSystemAccessId/8588884039428149248
* Revision: Rev 4.0, August 2014
.model OC_ALPHA-OMEGA-SEMICON_AON7400A VDMOS( VTO=1.9700000000e0 KP=3.2258064516e2 THETA=0.0000000000e0 LAMBDA=3.0000000000e-3 RD=3.4100000000e-3 RS=1.2400000000e-3 RG=1.0000000000e-4 RDS=1e9 CGS=1.0450000000e-9 CGDMAX=1.0500000000e-10 CGDMIN=1.0500000000e-10 CJO=7.5000000000e-11 IS=1.0000000000e-12 N=1.5000000000e0 RB=1.2400000000e-3)
