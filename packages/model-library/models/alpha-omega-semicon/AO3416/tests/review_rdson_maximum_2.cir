OpenCircuit independent review hard-bound probe
* OpenCircuit Model Factory v0.1.0 bulk adapter
* Original work generated from public factual specifications.
* This model is not copied or adapted from any vendor SPICE model.
* Source: https://jlcpcb.com/api/file/downloadByFileSystemAccessId/8586176348385103872
* Revision: Rev 5: July 2010
.model OC_ALPHA-OMEGA-SEMICON_AO3416 VDMOS( VTO=7.0000000000e-1 KP=1.2500000000e2 THETA=0.0000000000e0 LAMBDA=3.0000000000e-3 RD=8.8000000000e-3 RS=3.2000000000e-3 RG=1.0000000000e-4 RDS=1e9 CGS=1.2080000000e-9 CGDMAX=8.7000000000e-11 CGDMIN=8.7000000000e-11 CJO=7.3000000000e-11 IS=1.0000000000e-12 N=1.5000000000e0 RB=3.2000000000e-3)
.temp 25
M1 d g 0 OC_ALPHA-OMEGA-SEMICON_AO3416
ID 0 d DC 5.500000000000e+0
VG g 0 DC 2.500000000000e+0
.op
.end
