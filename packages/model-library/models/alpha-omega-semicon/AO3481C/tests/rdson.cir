OpenCircuit factory test: AO3481C RDS(on)
* OpenCircuit Model Factory v0.1.0 bulk adapter
* Original work generated from public factual specifications.
* This model is not copied or adapted from any vendor SPICE model.
* Source: https://jlcpcb.com/api/file/downloadByFileSystemAccessId/8589040584175079424
* Revision: Rev.2.0: November 2019
.model OC_ALPHA-OMEGA-SEMICON_AO3481C VDMOS( pchan VTO=-1.7000000000e0 KP=5.4054054054e1 THETA=0.0000000000e0 LAMBDA=3.0000000000e-3 RD=2.0350000000e-2 RS=7.4000000000e-3 RG=1.0000000000e-4 RDS=1e9 CGS=6.5000000000e-10 CGDMAX=7.0000000000e-11 CGDMIN=7.0000000000e-11 CJO=1.0000000000e-11 IS=1.0000000000e-12 N=1.5000000000e0 RB=7.4000000000e-3)

.temp 25
M1 d1 g1 0 OC_ALPHA-OMEGA-SEMICON_AO3481C
ID1 d1 0 DC 4.3000000000e0
VG1 g1 0 DC -1.0000000000e1
.op
.end
