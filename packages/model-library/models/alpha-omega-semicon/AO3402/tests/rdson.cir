OpenCircuit factory test: AO3402 RDS(on)
* OpenCircuit Model Factory v0.1.0 bulk adapter
* Original work generated from public factual specifications.
* This model is not copied or adapted from any vendor SPICE model.
* Source: https://jlcpcb.com/api/file/downloadByFileSystemAccessId/8586173502940991488
* Revision: Rev 6: Jan. 2011
.model OC_ALPHA-OMEGA-SEMICON_AO3402 VDMOS( VTO=1.0000000000e0 KP=4.6511627907e1 THETA=0.0000000000e0 LAMBDA=3.0000000000e-3 RD=2.3650000000e-2 RS=8.6000000000e-3 RG=1.0000000000e-4 RDS=1e9 CGS=2.1700000000e-10 CGDMAX=1.8000000000e-11 CGDMIN=1.8000000000e-11 CJO=1.7000000000e-11 IS=1.0000000000e-12 N=1.5000000000e0 RB=8.6000000000e-3)

.temp 25
M1 d1 g1 0 OC_ALPHA-OMEGA-SEMICON_AO3402
ID1 0 d1 DC 4.0000000000e0
VG1 g1 0 DC 1.0000000000e1
M2 d2 g2 0 OC_ALPHA-OMEGA-SEMICON_AO3402
ID2 0 d2 DC 4.0000000000e0
VG2 g2 0 DC 1.0000000000e1
M3 d3 g3 0 OC_ALPHA-OMEGA-SEMICON_AO3402
ID3 0 d3 DC 3.0000000000e0
VG3 g3 0 DC 4.5000000000e0
M4 d4 g4 0 OC_ALPHA-OMEGA-SEMICON_AO3402
ID4 0 d4 DC 3.0000000000e0
VG4 g4 0 DC 4.5000000000e0
M5 d5 g5 0 OC_ALPHA-OMEGA-SEMICON_AO3402
ID5 0 d5 DC 2.0000000000e0
VG5 g5 0 DC 2.5000000000e0
M6 d6 g6 0 OC_ALPHA-OMEGA-SEMICON_AO3402
ID6 0 d6 DC 2.0000000000e0
VG6 g6 0 DC 2.5000000000e0
.op
.end
