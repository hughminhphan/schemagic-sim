* OpenCircuit Model Factory v0.1.0 bulk adapter
* Original work generated from public factual specifications.
* This model is not copied or adapted from any vendor SPICE model.
* Source: https://jlcpcb.com/api/file/downloadByFileSystemAccessId/8586173502940991488
* Revision: Rev 6: Jan. 2011
.model OC_ALPHA-OMEGA-SEMICON_AO3402 VDMOS( VTO=1.0000000000e0 KP=4.6511627907e1 THETA=0.0000000000e0 LAMBDA=3.0000000000e-3 RD=2.3650000000e-2 RS=8.6000000000e-3 RG=1.0000000000e-4 RDS=1e9 CGS=2.1700000000e-10 CGDMAX=1.8000000000e-11 CGDMIN=1.8000000000e-11 CJO=1.7000000000e-11 IS=1.0000000000e-12 N=1.5000000000e0 RB=8.6000000000e-3)
