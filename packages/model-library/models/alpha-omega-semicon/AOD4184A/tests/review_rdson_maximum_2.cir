OpenCircuit independent review hard-bound probe
* OpenCircuit Model Factory v0.1.0 bulk adapter
* Original work generated from public factual specifications.
* This model is not copied or adapted from any vendor SPICE model.
* Source: https://jlcpcb.com/api/file/downloadByFileSystemAccessId/8586202483820023808
* Revision: Rev 0: Sep 2009
.model OC_ALPHA-OMEGA-SEMICON_AOD4184A VDMOS( VTO=2.1000000000e0 KP=3.4482758621e2 THETA=0.0000000000e0 LAMBDA=3.0000000000e-3 RD=3.1900000000e-3 RS=1.1600000000e-3 RG=1.0000000000e-4 RDS=1e9 CGS=1.3650000000e-9 CGDMAX=1.3500000000e-10 CGDMIN=1.3500000000e-10 CJO=8.0000000000e-11 IS=1.0000000000e-12 N=1.5000000000e0 RB=1.1600000000e-3)
.temp 25
M1 d g 0 OC_ALPHA-OMEGA-SEMICON_AOD4184A
ID 0 d DC 1.500000000000e+1
VG g 0 DC 4.500000000000e+0
.op
.end
