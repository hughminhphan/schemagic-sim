* OpenCircuit Model Factory v0.1.0 bulk adapter
* Original work generated from public factual specifications.
* This model is not copied or adapted from any vendor SPICE model.
* Source: https://jlcpcb.com/api/file/downloadByFileSystemAccessId/8588911092000542720
* Revision: Rev 0: April 2012
.model OC_ALPHA-OMEGA-SEMICON_AON7544 VDMOS( VTO=1.8000000000e0 KP=4.0000000000e2 THETA=0.0000000000e0 LAMBDA=3.0000000000e-3 RD=2.7500000000e-3 RS=1.0000000000e-3 RG=1.0000000000e-4 RDS=1e9 CGS=8.8900000000e-10 CGDMAX=6.2000000000e-11 CGDMIN=6.2000000000e-11 CJO=3.1100000000e-10 IS=1.0000000000e-12 N=1.5000000000e0 RB=1.0000000000e-3)
