OpenCircuit factory test: AO4459 RDS(on)
* OpenCircuit Model Factory v0.1.0 bulk adapter
* Original work generated from public factual specifications.
* This model is not copied or adapted from any vendor SPICE model.
* Source: https://jlcpcb.com/api/file/downloadByFileSystemAccessId/8586178786399936512
* Revision: Rev 2: Nov 2011
.model OC_ALPHA-OMEGA-SEMICON_AO4459 VDMOS( pchan VTO=-1.9000000000e0 KP=6.0606060606e1 THETA=0.0000000000e0 LAMBDA=3.0000000000e-3 RD=1.8150000000e-2 RS=6.6000000000e-3 RG=1.0000000000e-4 RDS=1e9 CGS=4.5500000000e-10 CGDMAX=6.5000000000e-11 CGDMIN=6.5000000000e-11 CJO=3.5000000000e-11 IS=1.0000000000e-12 N=1.5000000000e0 RB=6.6000000000e-3)

.temp 25
M1 d1 g1 0 OC_ALPHA-OMEGA-SEMICON_AO4459
ID1 d1 0 DC 6.5000000000e0
VG1 g1 0 DC -1.0000000000e1
.op
.end
