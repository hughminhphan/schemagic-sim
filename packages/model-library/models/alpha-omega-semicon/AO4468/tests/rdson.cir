OpenCircuit factory test: AO4468 RDS(on)
* OpenCircuit Model Factory v0.1.0 bulk adapter
* Original work generated from public factual specifications.
* This model is not copied or adapted from any vendor SPICE model.
* Source: https://jlcpcb.com/api/file/downloadByFileSystemAccessId/8586196556965535744
* Revision: Rev.7.0: July 2013
.model OC_ALPHA-OMEGA-SEMICON_AO4468 VDMOS( VTO=1.8000000000e0 KP=1.4285714286e2 THETA=0.0000000000e0 LAMBDA=3.0000000000e-3 RD=7.7000000000e-3 RS=2.8000000000e-3 RG=1.0000000000e-4 RDS=1e9 CGS=6.5800000000e-10 CGDMAX=8.2000000000e-11 CGDMIN=8.2000000000e-11 CJO=2.8000000000e-11 IS=1.0000000000e-12 N=1.5000000000e0 RB=2.8000000000e-3)

.temp 25
M1 d1 g1 0 OC_ALPHA-OMEGA-SEMICON_AO4468
ID1 0 d1 DC 1.0500000000e1
VG1 g1 0 DC 1.0000000000e1
.op
.end
