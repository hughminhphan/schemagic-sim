OpenCircuit factory test: SI2308A RDS(on)
* OpenCircuit Model Factory v0.1.0 bulk adapter
* Original work generated from public factual specifications.
* This model is not copied or adapted from any vendor SPICE model.
* Source: https://jlcpcb.com/api/file/downloadByFileSystemAccessId/8755881161933901824
* Revision: Nov.2024
.model OC_UMW-YOUTAI-SEMICONDUCTOR-CO-LTD_SI2308A VDMOS( VTO=3.0000000000e0 KP=2.5000000000e1 THETA=0.0000000000e0 LAMBDA=3.0000000000e-3 RD=4.4000000000e-2 RS=1.6000000000e-2 RG=1.0000000000e-4 RDS=1e9 CGS=2.2500000000e-10 CGDMAX=1.5000000000e-11 CGDMIN=1.5000000000e-11 CJO=3.5000000000e-11 IS=1.0000000000e-12 N=1.5000000000e0 RB=1.6000000000e-2)

.temp 25
M1 d1 g1 0 OC_UMW-YOUTAI-SEMICONDUCTOR-CO-LTD_SI2308A
ID1 0 d1 DC 3.0000000000e0
VG1 g1 0 DC 1.0000000000e1
M2 d2 g2 0 OC_UMW-YOUTAI-SEMICONDUCTOR-CO-LTD_SI2308A
ID2 0 d2 DC 1.9000000000e0
VG2 g2 0 DC 4.5000000000e0
.op
.end
