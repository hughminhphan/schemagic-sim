OpenCircuit factory test: SI2309A RDS(on)
* OpenCircuit Model Factory v0.1.0 bulk adapter
* Original work generated from public factual specifications.
* This model is not copied or adapted from any vendor SPICE model.
* Source: https://jlcpcb.com/api/file/downloadByFileSystemAccessId/8755880547556175872
* Revision: Nov.2024
.model OC_UMW-YOUTAI-SEMICONDUCTOR-CO-LTD_SI2309A VDMOS( pchan VTO=-3.0000000000e0 KP=5.8823529412e0 THETA=0.0000000000e0 LAMBDA=3.0000000000e-3 RD=1.8700000000e-1 RS=6.8000000000e-2 RG=1.0000000000e-4 RDS=1e9 CGS=2.3900000000e-10 CGDMAX=3.1000000000e-11 CGDMIN=3.1000000000e-11 CJO=1.3900000000e-10 IS=1.0000000000e-12 N=1.5000000000e0 RB=6.8000000000e-2)

.temp 25
M1 d1 g1 0 OC_UMW-YOUTAI-SEMICONDUCTOR-CO-LTD_SI2309A
ID1 d1 0 DC 1.2500000000e0
VG1 g1 0 DC -1.0000000000e1
M2 d2 g2 0 OC_UMW-YOUTAI-SEMICONDUCTOR-CO-LTD_SI2309A
ID2 d2 0 DC 1.0000000000e0
VG2 g2 0 DC -4.5000000000e0
.op
.end
