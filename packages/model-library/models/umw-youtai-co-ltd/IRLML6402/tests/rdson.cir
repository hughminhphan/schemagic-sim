OpenCircuit factory test: IRLML6402TR-UMW RDS(on)
* OpenCircuit Model Factory v0.1.0 bulk adapter
* Original work generated from public factual specifications.
* This model is not copied or adapted from any vendor SPICE model.
* Source: https://jlcpcb.com/api/file/downloadByFileSystemAccessId/8755878802461200384
* Revision: Nov.2024
.model OC_UMW-YOUTAI-SEMICONDUCTOR-CO-LTD_IRLML6402TR-UMW VDMOS( pchan VTO=-5.5000000000e-1 KP=4.0000000000e1 THETA=0.0000000000e0 LAMBDA=3.0000000000e-3 RD=2.7500000000e-2 RS=1.0000000000e-2 RG=1.0000000000e-4 RDS=1e9 CGS=5.2300000000e-10 CGDMAX=1.1000000000e-10 CGDMIN=1.1000000000e-10 CJO=3.5000000000e-11 IS=1.0000000000e-12 N=1.5000000000e0 RB=1.0000000000e-2)

.temp 25
M1 d1 g1 0 OC_UMW-YOUTAI-SEMICONDUCTOR-CO-LTD_IRLML6402TR-UMW
ID1 d1 0 DC 3.7000000000e0
VG1 g1 0 DC -4.5000000000e0
.op
.end
