OpenCircuit factory test: 15N10 RDS(on)
* OpenCircuit Model Factory v0.1.0 bulk adapter
* Original work generated from public factual specifications.
* This model is not copied or adapted from any vendor SPICE model.
* Source: https://jlcpcb.com/api/file/downloadByFileSystemAccessId/8755874864811261952
* Revision: Nov.2024
.model OC_UMW-YOUTAI-SEMICONDUCTOR-CO-LTD_15N10 VDMOS( VTO=1.6000000000e0 KP=2.1052631579e1 THETA=0.0000000000e0 LAMBDA=3.0000000000e-3 RD=5.2250000000e-2 RS=1.9000000000e-2 RG=1.0000000000e-4 RDS=1e9 CGS=6.1100000000e-10 CGDMAX=2.1000000000e-11 CGDMIN=2.1000000000e-11 CJO=1.6000000000e-11 IS=1.0000000000e-12 N=1.5000000000e0 RB=1.9000000000e-2)

.temp 25
M1 d1 g1 0 OC_UMW-YOUTAI-SEMICONDUCTOR-CO-LTD_15N10
ID1 0 d1 DC 1.0000000000e1
VG1 g1 0 DC 1.0000000000e1
M2 d2 g2 0 OC_UMW-YOUTAI-SEMICONDUCTOR-CO-LTD_15N10
ID2 0 d2 DC 1.0000000000e1
VG2 g2 0 DC 1.0000000000e1
M3 d3 g3 0 OC_UMW-YOUTAI-SEMICONDUCTOR-CO-LTD_15N10
ID3 0 d3 DC 5.0000000000e0
VG3 g3 0 DC 4.5000000000e0
M4 d4 g4 0 OC_UMW-YOUTAI-SEMICONDUCTOR-CO-LTD_15N10
ID4 0 d4 DC 5.0000000000e0
VG4 g4 0 DC 4.5000000000e0
.op
.end
