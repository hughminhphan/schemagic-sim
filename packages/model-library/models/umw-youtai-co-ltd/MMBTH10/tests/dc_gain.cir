OpenCircuit factory test: MMBTH10 DC gain
* OpenCircuit Model Factory v0.1.0 bulk adapter
* Original work generated from public factual specifications.
* This model is not copied or adapted from any vendor SPICE model.
* Source: https://jlcpcb.com/api/file/downloadByFileSystemAccessId/8588918221278101504
* Revision: REVERSE VOLTAGE V (V)
.model OC_UMW-YOUTAI-SEMICONDUCTOR-CO-LTD_MMBTH10 NPN(IS=1.0000000000e-14 BF=6.0000000000e1 VAF=1.0000000000e2 IKF=1.0000000000e3 RB=1.0000000000e1 RC=1.0000000000e-1 RE=5.0000000000e-2 CJE=1.0000000000e-12 CJC=1.0000000000e-12 TF=1.0000000000e-9)

.temp 25
VCG1 cg1 0 DC 1.0000000000e1
IBG1 0 bg1 DC 1.6666666667e-9
QG1 cg1 bg1 0 OC_UMW-YOUTAI-SEMICONDUCTOR-CO-LTD_MMBTH10
.op
.end
