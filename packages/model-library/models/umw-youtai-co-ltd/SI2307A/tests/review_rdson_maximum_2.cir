OpenCircuit independent review hard-bound probe
* OpenCircuit Model Factory v0.1.0 bulk adapter
* Original work generated from public factual specifications.
* This model is not copied or adapted from any vendor SPICE model.
* Source: https://jlcpcb.com/api/file/downloadByFileSystemAccessId/8755881151012069376
* Revision: Nov. 2024
.model OC_UMW-YOUTAI-SEMICONDUCTOR-CO-LTD_SI2307A VDMOS( pchan VTO=-3.0000000000e0 KP=4.4444444444e1 THETA=0.0000000000e0 LAMBDA=3.0000000000e-3 RD=2.4750000000e-2 RS=9.0000000000e-3 RG=1.0000000000e-4 RDS=1e9 CGS=4.9000000000e-10 CGDMAX=7.5000000000e-11 CGDMIN=7.5000000000e-11 CJO=5.1000000000e-11 IS=1.0000000000e-12 N=1.5000000000e0 RB=9.0000000000e-3)
.temp 25
M1 d g 0 OC_UMW-YOUTAI-SEMICONDUCTOR-CO-LTD_SI2307A
ID d 0 DC 2.500000000000e+0
VG g 0 DC -4.500000000000e+0
.op
.end
