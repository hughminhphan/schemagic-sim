OpenCircuit factory test: AO3415A RDS(on)
* OpenCircuit Model Factory v0.1.0 bulk adapter
* Original work generated from public factual specifications.
* This model is not copied or adapted from any vendor SPICE model.
* Source: https://jlcpcb.com/api/file/downloadByFileSystemAccessId/8755874812222672896
* Revision: Nov. 2024
.model OC_UMW-YOUTAI-SEMICONDUCTOR-CO-LTD_AO3415A VDMOS( pchan VTO=-5.6000000000e-1 KP=5.8823529412e1 THETA=0.0000000000e0 LAMBDA=3.0000000000e-3 RD=1.8700000000e-2 RS=6.8000000000e-3 RG=1.0000000000e-4 RDS=1e9 CGS=1.2900000000e-9 CGDMAX=1.6000000000e-10 CGDMIN=1.6000000000e-10 CJO=4.5000000000e-11 IS=1.0000000000e-12 N=1.5000000000e0 RB=6.8000000000e-3)

.temp 25
M1 d1 g1 0 OC_UMW-YOUTAI-SEMICONDUCTOR-CO-LTD_AO3415A
ID1 d1 0 DC 4.0000000000e0
VG1 g1 0 DC -4.5000000000e0
M2 d2 g2 0 OC_UMW-YOUTAI-SEMICONDUCTOR-CO-LTD_AO3415A
ID2 d2 0 DC 4.0000000000e0
VG2 g2 0 DC -4.5000000000e0
M3 d3 g3 0 OC_UMW-YOUTAI-SEMICONDUCTOR-CO-LTD_AO3415A
ID3 d3 0 DC 4.0000000000e0
VG3 g3 0 DC -2.5000000000e0
M4 d4 g4 0 OC_UMW-YOUTAI-SEMICONDUCTOR-CO-LTD_AO3415A
ID4 d4 0 DC 4.0000000000e0
VG4 g4 0 DC -2.5000000000e0
.op
.end
