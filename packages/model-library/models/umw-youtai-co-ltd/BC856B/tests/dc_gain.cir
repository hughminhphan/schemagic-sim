OpenCircuit factory test: BC856B DC gain
* OpenCircuit Model Factory v0.1.0 bulk adapter
* Original work generated from public factual specifications.
* This model is not copied or adapted from any vendor SPICE model.
* Source: https://jlcpcb.com/api/file/downloadByFileSystemAccessId/8588907071035490304
* Revision: Not stated in supplied datasheet
.model OC_UMW-YOUTAI-SEMICONDUCTOR-CO-LTD_BC856B PNP(IS=1.0000000000e-14 BF=3.3420061613e2 VAF=1.0000000000e2 IKF=1.3094547893e-1 RB=1.0000000000e1 RC=1.0000000000e-1 RE=5.0000000000e-2 CJE=1.0000000000e-12 CJC=1.0000000000e-12 TF=1.0000000000e-9)

.temp 25
VCG1 cg1 0 DC -5.0000000000e0
IBG1 0 bg1 DC -2.8571428571e-7
QG1 cg1 bg1 0 OC_UMW-YOUTAI-SEMICONDUCTOR-CO-LTD_BC856B
VCG2 cg2 0 DC -5.0000000000e0
IBG2 0 bg2 DC -2.8571428571e-6
QG2 cg2 bg2 0 OC_UMW-YOUTAI-SEMICONDUCTOR-CO-LTD_BC856B
VCG3 cg3 0 DC -5.0000000000e0
IBG3 0 bg3 DC -5.8823529412e-6
QG3 cg3 bg3 0 OC_UMW-YOUTAI-SEMICONDUCTOR-CO-LTD_BC856B
VCG4 cg4 0 DC -5.0000000000e0
IBG4 0 bg4 DC -3.1250000000e-5
QG4 cg4 bg4 0 OC_UMW-YOUTAI-SEMICONDUCTOR-CO-LTD_BC856B
VCG5 cg5 0 DC -5.0000000000e0
IBG5 0 bg5 DC -1.0344827586e-4
QG5 cg5 bg5 0 OC_UMW-YOUTAI-SEMICONDUCTOR-CO-LTD_BC856B
VCG6 cg6 0 DC -5.0000000000e0
IBG6 0 bg6 DC -5.0000000000e-4
QG6 cg6 bg6 0 OC_UMW-YOUTAI-SEMICONDUCTOR-CO-LTD_BC856B
VCG7 cg7 0 DC -5.0000000000e0
IBG7 0 bg7 DC -9.0909090909e-6
QG7 cg7 bg7 0 OC_UMW-YOUTAI-SEMICONDUCTOR-CO-LTD_BC856B
VCG8 cg8 0 DC -5.0000000000e0
IBG8 0 bg8 DC -4.2105263158e-6
QG8 cg8 bg8 0 OC_UMW-YOUTAI-SEMICONDUCTOR-CO-LTD_BC856B
.op
.end
