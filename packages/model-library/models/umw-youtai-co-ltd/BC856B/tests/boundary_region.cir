OpenCircuit factory test: BC856B supported-region upper-current boundary
* OpenCircuit Model Factory v0.1.0 bulk adapter
* Original work generated from public factual specifications.
* This model is not copied or adapted from any vendor SPICE model.
* Source: https://jlcpcb.com/api/file/downloadByFileSystemAccessId/8588907071035490304
* Revision: Not stated in supplied datasheet
.model OC_UMW-YOUTAI-SEMICONDUCTOR-CO-LTD_BC856B PNP(IS=1.0000000000e-14 BF=3.3420061613e2 VAF=1.0000000000e2 IKF=1.3094547893e-1 RB=1.0000000000e1 RC=1.0000000000e-1 RE=5.0000000000e-2 CJE=1.0000000000e-12 CJC=1.0000000000e-12 TF=1.0000000000e-9)

.temp 25
IC 0 c DC -1.0000000000e-1
IB 0 b DC -5.0000000000e-4
Q1 c b 0 OC_UMW-YOUTAI-SEMICONDUCTOR-CO-LTD_BC856B
.op
.end
