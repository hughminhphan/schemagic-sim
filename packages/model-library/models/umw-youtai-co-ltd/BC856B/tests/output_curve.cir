OpenCircuit factory test: BC856B output sanity
* OpenCircuit Model Factory v0.1.0 bulk adapter
* Original work generated from public factual specifications.
* This model is not copied or adapted from any vendor SPICE model.
* Source: https://jlcpcb.com/api/file/downloadByFileSystemAccessId/8588907071035490304
* Revision: Not stated in supplied datasheet
.model OC_UMW-YOUTAI-SEMICONDUCTOR-CO-LTD_BC856B PNP(IS=1.0000000000e-14 BF=3.3420061613e2 VAF=1.0000000000e2 IKF=1.3094547893e-1 RB=1.0000000000e1 RC=1.0000000000e-1 RE=5.0000000000e-2 CJE=1.0000000000e-12 CJC=1.0000000000e-12 TF=1.0000000000e-9)

.temp 25
VCE1 c1 0 DC -2
IB1 0 b1 DC -0.00001
Q1 c1 b1 0 OC_UMW-YOUTAI-SEMICONDUCTOR-CO-LTD_BC856B
VCE2 c2 0 DC -10
IB2 0 b2 DC -0.00005
Q2 c2 b2 0 OC_UMW-YOUTAI-SEMICONDUCTOR-CO-LTD_BC856B
.op
.end
