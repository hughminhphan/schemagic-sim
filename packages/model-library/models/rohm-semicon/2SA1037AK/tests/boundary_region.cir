OpenCircuit factory test: 2SA1037AKT146R supported-region upper-current boundary
* OpenCircuit Model Factory v0.1.0 bulk adapter
* Original work generated from public factual specifications.
* This model is not copied or adapted from any vendor SPICE model.
* Source: https://jlcpcb.com/api/file/downloadByFileSystemAccessId/8586202896555233280
* Revision: 20150909 - Rev.003
.model OC_ROHM-SEMICON_2SA1037AKT146R PNP(IS=1.0000000000e-14 BF=2.3600000000e2 VAF=1.0000000000e2 IKF=1.0000000000e3 RB=1.0000000000e1 RC=1.0000000000e-1 RE=5.0000000000e-2 CJE=1.0000000000e-12 CJC=1.0000000000e-12 TF=1.0000000000e-9)

.temp 25
IC 0 c DC -1.0000000000e-3
IB 0 b DC -8.3333333333e-6
Q1 c b 0 OC_ROHM-SEMICON_2SA1037AKT146R
.op
.end
