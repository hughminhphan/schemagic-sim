OpenCircuit factory test: RZM002P02T2L RDS(on)
* OpenCircuit Model Factory v0.1.0 bulk adapter
* Original work generated from public factual specifications.
* This model is not copied or adapted from any vendor SPICE model.
* Source: https://jlcpcb.com/api/file/downloadByFileSystemAccessId/8588906734199324672
* Revision: 20160630 - Rev.001
.model OC_ROHM-SEMICON_RZM002P02T2L VDMOS( pchan VTO=-1.0000000000e0 KP=2.5000000000e0 THETA=0.0000000000e0 LAMBDA=3.0000000000e-3 RD=4.4000000000e-1 RS=1.6000000000e-1 RG=1.0000000000e-4 RDS=1e9 CGS=1.0900000000e-10 CGDMAX=6.0000000000e-12 CGDMIN=6.0000000000e-12 CJO=4.0000000000e-12 IS=1.0000000000e-12 N=1.5000000000e0 RB=1.6000000000e-1)

.temp 25
M1 d1 g1 0 OC_ROHM-SEMICON_RZM002P02T2L
ID1 d1 0 DC 2.0000000000e-1
VG1 g1 0 DC -4.5000000000e0
.op
.end
