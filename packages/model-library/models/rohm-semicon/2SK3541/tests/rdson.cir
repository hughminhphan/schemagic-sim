OpenCircuit factory test: 2SK3541T2L RDS(on)
* OpenCircuit Model Factory v0.1.0 bulk adapter
* Original work generated from public factual specifications.
* This model is not copied or adapted from any vendor SPICE model.
* Source: https://jlcpcb.com/api/file/downloadByFileSystemAccessId/8586202741890408448
* Revision: Rev.B
.model OC_ROHM-SEMICON_2SK3541T2L VDMOS( VTO=1.5000000000e0 KP=4.0000000000e-1 THETA=0.0000000000e0 LAMBDA=3.0000000000e-3 RD=2.7500000000e0 RS=1.0000000000e0 RG=1.0000000000e-4 RDS=1e9 CGS=9.0000000000e-12 CGDMAX=4.0000000000e-12 CGDMIN=4.0000000000e-12 CJO=5.0000000000e-12 IS=1.0000000000e-12 N=1.5000000000e0 RB=1.0000000000e0)

.temp 25
M1 d1 g1 0 OC_ROHM-SEMICON_2SK3541T2L
ID1 0 d1 DC 1.0000000000e-2
VG1 g1 0 DC 4.0000000000e0
.op
.end
