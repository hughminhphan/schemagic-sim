OpenCircuit factory test: forward_06.cir
* OpenCircuit Model Factory v0.1.0 bulk adapter
* Original work generated from public factual specifications.
* This model is not copied or adapted from any vendor SPICE model.
* Source: https://jlcpcb.com/api/file/downloadByFileSystemAccessId/8589042142308683776
* Revision: 2016.02 - Rev.001
.model OC_ROHM-SEMICON_RB161QS-40T18R D(IS=2.4423154239e-7 N=1.0275264801e0 RS=7.8219629630e-2)

.temp 25
Itest 0 anode DC 1.0000000000e-3
Vanchor anchor 0 DC 0
Ranchor anchor 0 1G
Ddut anode 0 OC_ROHM-SEMICON_RB161QS-40T18R
.op
.end
