OpenCircuit independent review hard-bound probe
* OpenCircuit Model Factory v0.1.0 bulk adapter
* Original work generated from public factual specifications.
* This model is not copied or adapted from any vendor SPICE model.
* Source: https://jlcpcb.com/api/file/downloadByFileSystemAccessId/8588918458561650688
* Revision: 20160630 - Rev.001
.model OC_ROHM-SEMICON_RUM002N02T2L VDMOS( VTO=1.0000000000e0 KP=2.5000000000e0 THETA=0.0000000000e0 LAMBDA=3.0000000000e-3 RD=4.4000000000e-1 RS=1.6000000000e-1 RG=1.0000000000e-4 RDS=1e9 CGS=1.5000000000e-11 CGDMAX=1.0000000000e-11 CGDMIN=1.0000000000e-11 CJO=1.0000000000e-15 IS=1.0000000000e-12 N=1.5000000000e0 RB=1.6000000000e-1)
.temp 25
M1 d g 0 OC_ROHM-SEMICON_RUM002N02T2L
ID 0 d DC 2.000000000000e-2
VG g 0 DC 1.200000000000e+0
.op
.end
