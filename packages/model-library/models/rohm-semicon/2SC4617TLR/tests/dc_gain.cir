OpenCircuit factory test: 2SC4617TLR DC gain
* OpenCircuit Model Factory v0.1.0 bulk adapter
* Original work generated from public factual specifications.
* This model is not copied or adapted from any vendor SPICE model.
* Source: https://jlcpcb.com/api/file/downloadByFileSystemAccessId/8586202894110900224
* Revision: Rev. 003
.model OC_ROHM-SEMICON_2SC4617TLR NPN(IS=1.0000000000e-14 BF=1.8180000000e2 VAF=1.0000000000e2 IKF=1.0000000000e3 RB=1.0000000000e1 RC=1.0000000000e-1 RE=5.0000000000e-2 CJE=1.0000000000e-12 CJC=1.0000000000e-12 TF=1.0000000000e-9)

.temp 25
VCG1 cg1 0 DC 6.0000000000e0
IBG1 0 bg1 DC 5.5555555556e-6
QG1 cg1 bg1 0 OC_ROHM-SEMICON_2SC4617TLR
.op
.end
