Batch 9 independent review: 2SC4617TLR exact gain hard bounds
* Public datasheet facts only; no vendor SPICE model used.
.model OC_ROHM-SEMICON_2SC4617TLR NPN(IS=1.0000000000e-14 BF=1.8180000000e2 VAF=1.0000000000e2 IKF=1.0000000000e3 RB=1.0000000000e1 RC=1.0000000000e-1 RE=5.0000000000e-2 CJE=1.0000000000e-12 CJC=1.0000000000e-12 TF=1.0000000000e-9)

.temp 25
VCG1 cg1 0 DC 6
IBG1 0 bg1 DC 5.2215858924982038e-06
QG1 cg1 bg1 0 OC_ROHM-SEMICON_2SC4617TLR
.op
.end
