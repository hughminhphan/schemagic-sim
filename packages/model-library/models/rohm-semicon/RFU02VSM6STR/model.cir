* OpenCircuit Model Factory v0.1.0 bulk adapter
* Original work generated from public factual specifications.
* This model is not copied or adapted from any vendor SPICE model.
* Source: https://jlcpcb.com/api/file/downloadByFileSystemAccessId/8589839471958401024
* Revision: 2015.12 - Rev.A
.model OC_ROHM-SEMICON_RFU02VSM6STR D(IS=1.6404717708e-15 N=1.8000000000e0 RS=1.0000000000e-4)
