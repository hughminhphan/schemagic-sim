OpenCircuit factory test: 2SC2412KT146R DC gain
* OpenCircuit Model Factory v0.1.0 bulk adapter
* Original work generated from public factual specifications.
* This model is not copied or adapted from any vendor SPICE model.
* Source: https://jlcpcb.com/api/file/downloadByFileSystemAccessId/8586202910383853568
* Revision: 20150824 - Rev.003
.model OC_ROHM-SEMICON_2SC2412KT146R NPN(IS=1.0000000000e-14 BF=2.5900000000e2 VAF=1.0000000000e2 IKF=1.0000000000e3 RB=1.0000000000e1 RC=1.0000000000e-1 RE=5.0000000000e-2 CJE=1.0000000000e-12 CJC=1.0000000000e-12 TF=1.0000000000e-9)

.temp 25
VCG1 cg1 0 DC 6.0000000000e0
IBG1 0 bg1 DC 8.3333333333e-6
QG1 cg1 bg1 0 OC_ROHM-SEMICON_2SC2412KT146R
VCG2 cg2 0 DC 6.0000000000e0
IBG2 0 bg2 DC 3.8610038610e-6
QG2 cg2 bg2 0 OC_ROHM-SEMICON_2SC2412KT146R
.op
.end
