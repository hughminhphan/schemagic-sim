OpenCircuit independent review hard-bound probe
* OpenCircuit Model Factory v0.1.0 bulk adapter
* Original work generated from public factual specifications.
* This model is not copied or adapted from any vendor SPICE model.
* Source: https://jlcpcb.com/api/file/downloadByFileSystemAccessId/8586202910383853568
* Revision: 20150824 - Rev.003
.model OC_ROHM-SEMICON_2SC2412KT146R NPN(IS=1.0000000000e-14 BF=2.5900000000e2 VAF=1.0000000000e2 IKF=1.0000000000e3 RB=1.0000000000e1 RC=1.0000000000e-1 RE=5.0000000000e-2 CJE=1.0000000000e-12 CJC=1.0000000000e-12 TF=1.0000000000e-9)
.temp 25
VC c 0 DC 6.0
IB 0 b DC 1.7857142857142857e-06
Q c b 0 OC_ROHM-SEMICON_2SC2412KT146R
.op
.end
