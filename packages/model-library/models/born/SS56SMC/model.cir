* OpenCircuit Model Factory v0.1.0 bulk adapter
* Original work generated from public factual specifications.
* This model is not copied or adapted from any vendor SPICE model.
* Source: https://jlcpcb.com/api/file/downloadByFileSystemAccessId/8588905433109041152
* Revision: revision not stated in source
.model OC_BORN_SS56SMC D(IS=3.3378809841e-14 N=1.1000000000e0 RS=1.0000000000e-4)
