OpenCircuit factory test: forward_14.cir
* OpenCircuit Model Factory v0.1.0 bulk adapter
* Original work generated from public factual specifications.
* This model is not copied or adapted from any vendor SPICE model.
* Source: https://jlcpcb.com/api/file/downloadByFileSystemAccessId/8588885146829262848
* Revision: Rev 8: Nov 2014
.model OC_BORN_DSS26 D(IS=7.0912606364e-6 N=1.6099936373e0 RS=1.7509617337e-2)

.temp 25
Itest 0 anode DC 2.0000000000e1
Vanchor anchor 0 DC 0
Ranchor anchor 0 1G
Ddut anode 0 OC_BORN_DSS26
.op
.end
