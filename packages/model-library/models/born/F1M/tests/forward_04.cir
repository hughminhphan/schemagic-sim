OpenCircuit factory test: forward_04.cir
* OpenCircuit Model Factory v0.1.0 bulk adapter
* Original work generated from public factual specifications.
* This model is not copied or adapted from any vendor SPICE model.
* Source: https://jlcpcb.com/api/file/downloadByFileSystemAccessId/8603356969197985792
* Revision: Revision 2018
.model OC_BORN_F1M D(IS=2.5007036464e-20 N=9.9257553305e-1 RS=1.3481800819e-2)

.temp 2.5000000000e1
Itest 0 anode DC 2.0000000000e0
Vanchor anchor 0 DC 0
Ranchor anchor 0 1G
Ddut anode 0 OC_BORN_F1M
.op
.end
