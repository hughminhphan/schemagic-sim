* OpenCircuit Model Factory v0.1.0 bulk adapter
* Original work generated from public factual specifications.
* This model is not copied or adapted from any vendor SPICE model.
* Source: https://jlcpcb.com/api/file/downloadByFileSystemAccessId/8588905215265820672
* Revision: Revision 2018
.model OC_BORN_SI2309 VDMOS( pchan VTO=-1.5000000000e0 KP=1.3333333333e1 THETA=0.0000000000e0 LAMBDA=3.0000000000e-3 RD=8.2500000000e-2 RS=3.0000000000e-2 RG=1.0000000000e-4 RDS=1e9 CGS=2.9500000000e-10 CGDMAX=1.5000000000e-11 CGDMIN=1.5000000000e-11 CJO=7.0000000000e-12 IS=1.0000000000e-12 N=1.5000000000e0 RB=3.0000000000e-2)
