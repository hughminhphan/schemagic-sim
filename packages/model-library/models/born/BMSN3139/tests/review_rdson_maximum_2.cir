OpenCircuit independent review hard-bound probe
* OpenCircuit Model Factory v0.1.0 bulk adapter
* Original work generated from public factual specifications.
* This model is not copied or adapted from any vendor SPICE model.
* Source: https://jlcpcb.com/api/file/downloadByFileSystemAccessId/8603011965522354176
* Revision: Revision 2018
.model OC_BORN_BMSN3139 VDMOS( pchan VTO=-1.1000000000e0 KP=1.6460905350e1 THETA=0.0000000000e0 LAMBDA=3.0000000000e-3 RD=6.6825000000e-2 RS=2.4300000000e-2 RG=1.0000000000e-4 RDS=1e9 CGS=3.5000000000e-10 CGDMAX=5.5000000000e-11 CGDMIN=5.5000000000e-11 CJO=2.0000000000e-11 IS=1.0000000000e-12 N=1.5000000000e0 RB=2.4300000000e-2)
.temp 25
M1 d g 0 OC_BORN_BMSN3139
ID d 0 DC 1.500000000000e+0
VG g 0 DC -2.500000000000e+0
.op
.end
