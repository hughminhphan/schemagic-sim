OpenCircuit factory test: reverse leakage
* OpenCircuit Model Factory v0.1.0 bulk adapter
* Original work generated from public factual specifications.
* This model is not copied or adapted from any vendor SPICE model.
* Source: https://jlcpcb.com/api/file/downloadByFileSystemAccessId/8588905497655590912
* Revision: Revision 2018
.model OC_BORN_DSS210 D(IS=1.1489328867e-6 N=1.8004110008e0 RS=3.6551335202e-2)

.temp 25
Vreverse cathode 0 DC 1.0000000000e2
Ddut 0 cathode OC_BORN_DSS210
.op
.end
