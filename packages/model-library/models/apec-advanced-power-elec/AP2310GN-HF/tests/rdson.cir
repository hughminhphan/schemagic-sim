OpenCircuit factory test: AP2310GN-HF RDS(on)
* OpenCircuit Model Factory v0.1.0 bulk adapter
* Original work generated from public factual specifications.
* This model is not copied or adapted from any vendor SPICE model.
* Source: https://jlcpcb.com/api/file/downloadByFileSystemAccessId/8586176378400354304
* Revision: Document code 201410204
.model OC_APEC-ADVANCED-POWER-ELEC_AP2310GN-HF VDMOS( VTO=1.5500000000e0 KP=2.8571428571e1 THETA=0.0000000000e0 LAMBDA=3.0000000000e-3 RD=3.8500000000e-2 RS=1.4000000000e-2 RG=1.0000000000e-4 RDS=1e9 CGS=5.0000000000e-10 CGDMAX=5.0000000000e-11 CGDMIN=5.0000000000e-11 CJO=2.0000000000e-11 IS=1.0000000000e-12 N=1.5000000000e0 RB=1.4000000000e-2)

.temp 25
M1 d1 g1 0 OC_APEC-ADVANCED-POWER-ELEC_AP2310GN-HF
ID1 0 d1 DC 3.0000000000e0
VG1 g1 0 DC 1.0000000000e1
.op
.end
