OpenCircuit factory test: APM4953 RDS(on)
* OpenCircuit Model Factory v0.1.0 bulk adapter
* Original work generated from public factual specifications.
* This model is not copied or adapted from any vendor SPICE model.
* Source: https://jlcpcb.com/api/file/downloadByFileSystemAccessId/8608745005884321792
* Revision: Rev-1.4
.model OC_ELECSUPER_APM4953 VDMOS( pchan VTO=-1.5000000000e0 KP=5.0000000000e1 THETA=0.0000000000e0 LAMBDA=3.0000000000e-3 RD=2.2000000000e-2 RS=8.0000000000e-3 RG=1.0000000000e-4 RDS=1e9 CGS=4.5500000000e-10 CGDMAX=6.5000000000e-11 CGDMIN=6.5000000000e-11 CJO=3.5000000000e-11 IS=1.0000000000e-12 N=1.5000000000e0 RB=8.0000000000e-3)

.temp 25
M1 d1 g1 0 OC_ELECSUPER_APM4953
ID1 d1 0 DC 5.0000000000e0
VG1 g1 0 DC -1.0000000000e1
.op
.end
