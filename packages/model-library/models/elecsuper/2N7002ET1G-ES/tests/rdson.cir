OpenCircuit factory test: 2N7002ET1G-ES RDS(on)
* OpenCircuit Model Factory v0.1.0 bulk adapter
* Original work generated from public factual specifications.
* This model is not copied or adapted from any vendor SPICE model.
* Source: https://jlcpcb.com/api/file/downloadByFileSystemAccessId/8608743293040160768
* Revision: Rev-1.6
.model OC_ELECSUPER_2N7002ET1G-ES VDMOS( VTO=1.6000000000e0 KP=1.0810810811e0 THETA=0.0000000000e0 LAMBDA=3.0000000000e-3 RD=1.0175000000e0 RS=3.7000000000e-1 RG=1.0000000000e-4 RDS=1e9 CGS=2.4000000000e-11 CGDMAX=4.0000000000e-12 CGDMIN=4.0000000000e-12 CJO=7.0000000000e-12 IS=1.0000000000e-12 N=1.5000000000e0 RB=3.7000000000e-1)

.temp 25
M1 d1 g1 0 OC_ELECSUPER_2N7002ET1G-ES
ID1 0 d1 DC 3.0000000000e-1
VG1 g1 0 DC 1.0000000000e1
.op
.end
