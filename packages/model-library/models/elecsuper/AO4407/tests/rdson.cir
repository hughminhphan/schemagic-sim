OpenCircuit factory test: AO4407 RDS(on)
* OpenCircuit Model Factory v0.1.0 bulk adapter
* Original work generated from public factual specifications.
* This model is not copied or adapted from any vendor SPICE model.
* Source: https://jlcpcb.com/api/file/downloadByFileSystemAccessId/8608744935894511616
* Revision: Rev-1.7
.model OC_ELECSUPER_AO4407 VDMOS( pchan VTO=-1.5000000000e0 KP=2.1052631579e2 THETA=0.0000000000e0 LAMBDA=3.0000000000e-3 RD=5.2250000000e-3 RS=1.9000000000e-3 RG=1.0000000000e-4 RDS=1e9 CGS=1.5800000000e-9 CGDMAX=2.0000000000e-10 CGDMIN=2.0000000000e-10 CJO=3.5000000000e-11 IS=1.0000000000e-12 N=1.5000000000e0 RB=1.9000000000e-3)

.temp 25
M1 d1 g1 0 OC_ELECSUPER_AO4407
ID1 d1 0 DC 1.2000000000e1
VG1 g1 0 DC -1.0000000000e1
.op
.end
