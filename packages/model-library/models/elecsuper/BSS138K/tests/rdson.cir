OpenCircuit factory test: BSS138K RDS(on)
* OpenCircuit Model Factory v0.1.0 bulk adapter
* Original work generated from public factual specifications.
* This model is not copied or adapted from any vendor SPICE model.
* Source: https://jlcpcb.com/api/file/downloadByFileSystemAccessId/8608743870214004736
* Revision: Rev-1.3
.model OC_ELECSUPER_BSS138K VDMOS( VTO=1.0000000000e0 KP=1.3333333333e0 THETA=0.0000000000e0 LAMBDA=3.0000000000e-3 RD=8.2500000000e-1 RS=3.0000000000e-1 RG=1.0000000000e-4 RDS=1e9 CGS=2.2800000000e-11 CGDMAX=2.2000000000e-12 CGDMIN=2.2000000000e-12 CJO=7.5000000000e-12 IS=1.0000000000e-12 N=1.5000000000e0 RB=3.0000000000e-1)

.temp 25
M1 d1 g1 0 OC_ELECSUPER_BSS138K
ID1 0 d1 DC 4.0000000000e-1
VG1 g1 0 DC 1.0000000000e1
M2 d2 g2 0 OC_ELECSUPER_BSS138K
ID2 0 d2 DC 4.0000000000e-1
VG2 g2 0 DC 1.0000000000e1
M3 d3 g3 0 OC_ELECSUPER_BSS138K
ID3 0 d3 DC 2.0000000000e-1
VG3 g3 0 DC 4.5000000000e0
M4 d4 g4 0 OC_ELECSUPER_BSS138K
ID4 0 d4 DC 2.0000000000e-1
VG4 g4 0 DC 4.5000000000e0
M5 d5 g5 0 OC_ELECSUPER_BSS138K
ID5 0 d5 DC 1.0000000000e-1
VG5 g5 0 DC 2.5000000000e0
M6 d6 g6 0 OC_ELECSUPER_BSS138K
ID6 0 d6 DC 1.0000000000e-1
VG6 g6 0 DC 2.5000000000e0
.op
.end
