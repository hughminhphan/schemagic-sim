* OpenCircuit Model Factory v0.1.0 bulk adapter
* Original work generated from public factual specifications.
* This model is not copied or adapted from any vendor SPICE model.
* Source: https://jlcpcb.com/api/file/downloadByFileSystemAccessId/8588898886346162176
* Revision: Rev.06.2
.model OC_SHANGHAI-PRISEMI-ELEC_PSBD2FD30V01 D(IS=5.7637670174e-8 N=1.1000000000e0 RS=1.0000000000e-4)
