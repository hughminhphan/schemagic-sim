OpenCircuit factory test: 2N3904S-RTK-PS saturation
* OpenCircuit Model Factory v0.1.0 bulk adapter
* Original work generated from public factual specifications.
* This model is not copied or adapted from any vendor SPICE model.
* Source: https://jlcpcb.com/api/file/downloadByFileSystemAccessId/8586173324804706304
* Revision: Revision No. 3, dated 2003-02-25
.model OC_KEC-SEMICON_2N3904S-RTK-PS NPN(IS=1.0000000000e-14 BF=2.7826538024e2 VAF=1.0000000000e2 IKF=3.4597985341e-2 ISE=7.4151771851e-14 NE=1.5000000000e0 NF=1.0000000000e0 RB=1.0000000000e1 RC=1.0000000000e-1 RE=5.0000000000e-2 CJE=1.0000000000e-12 CJC=1.0000000000e-12 TF=1.0000000000e-9)

.temp 25
ICS1 0 cs1 DC 1.0000000000e-2
IBS1 0 bs1 DC 1.0000000000e-3
QS1 cs1 bs1 0 OC_KEC-SEMICON_2N3904S-RTK-PS
ICS2 0 cs2 DC 1.0000000000e-2
IBS2 0 bs2 DC 1.0000000000e-3
QS2 cs2 bs2 0 OC_KEC-SEMICON_2N3904S-RTK-PS
ICS3 0 cs3 DC 5.0000000000e-2
IBS3 0 bs3 DC 5.0000000000e-3
QS3 cs3 bs3 0 OC_KEC-SEMICON_2N3904S-RTK-PS
.op
.end
