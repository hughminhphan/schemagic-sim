OpenCircuit factory test: 2N3904S-RTK-PS supported-region upper-current boundary
* OpenCircuit Model Factory v0.1.0 bulk adapter
* Original work generated from public factual specifications.
* This model is not copied or adapted from any vendor SPICE model.
* Source: https://jlcpcb.com/api/file/downloadByFileSystemAccessId/8586173324804706304
* Revision: Revision No. 3, dated 2003-02-25
.model OC_KEC-SEMICON_2N3904S-RTK-PS NPN(IS=1.0000000000e-14 BF=2.7826538024e2 VAF=1.0000000000e2 IKF=3.4597985341e-2 ISE=7.4151771851e-14 NE=1.5000000000e0 NF=1.0000000000e0 RB=1.0000000000e1 RC=1.0000000000e-1 RE=5.0000000000e-2 CJE=1.0000000000e-12 CJC=1.0000000000e-12 TF=1.0000000000e-9)

.temp 25
IC 0 c DC 3.0000000000e-1
IB 0 b DC 1.3636363636e-2
Q1 c b 0 OC_KEC-SEMICON_2N3904S-RTK-PS
.op
.end
