OpenCircuit factory test: 2N3904S-RTK-PS DC gain
* OpenCircuit Model Factory v0.1.0 bulk adapter
* Original work generated from public factual specifications.
* This model is not copied or adapted from any vendor SPICE model.
* Source: https://jlcpcb.com/api/file/downloadByFileSystemAccessId/8586173324804706304
* Revision: Revision No. 3, dated 2003-02-25
.model OC_KEC-SEMICON_2N3904S-RTK-PS NPN(IS=1.0000000000e-14 BF=2.7826538024e2 VAF=1.0000000000e2 IKF=3.4597985341e-2 ISE=7.4151771851e-14 NE=1.5000000000e0 NF=1.0000000000e0 RB=1.0000000000e1 RC=1.0000000000e-1 RE=5.0000000000e-2 CJE=1.0000000000e-12 CJC=1.0000000000e-12 TF=1.0000000000e-9)

.temp 25
VCG1 cg1 0 DC 1.0000000000e0
IBG1 0 bg1 DC 6.6666666667e-7
QG1 cg1 bg1 0 OC_KEC-SEMICON_2N3904S-RTK-PS
VCG2 cg2 0 DC 1.0000000000e0
IBG2 0 bg2 DC 1.8750000000e-6
QG2 cg2 bg2 0 OC_KEC-SEMICON_2N3904S-RTK-PS
VCG3 cg3 0 DC 1.0000000000e0
IBG3 0 bg3 DC 5.7142857143e-6
QG3 cg3 bg3 0 OC_KEC-SEMICON_2N3904S-RTK-PS
VCG4 cg4 0 DC 1.0000000000e0
IBG4 0 bg4 DC 1.5789473684e-5
QG4 cg4 bg4 0 OC_KEC-SEMICON_2N3904S-RTK-PS
VCG5 cg5 0 DC 1.0000000000e0
IBG5 0 bg5 DC 5.2631578947e-5
QG5 cg5 bg5 0 OC_KEC-SEMICON_2N3904S-RTK-PS
VCG6 cg6 0 DC 1.0000000000e0
IBG6 0 bg6 DC 1.7647058824e-4
QG6 cg6 bg6 0 OC_KEC-SEMICON_2N3904S-RTK-PS
VCG7 cg7 0 DC 1.0000000000e0
IBG7 0 bg7 DC 1.4285714286e-3
QG7 cg7 bg7 0 OC_KEC-SEMICON_2N3904S-RTK-PS
VCG8 cg8 0 DC 1.0000000000e0
IBG8 0 bg8 DC 1.3636363636e-2
QG8 cg8 bg8 0 OC_KEC-SEMICON_2N3904S-RTK-PS
VCG9 cg9 0 DC 1.0000000000e0
IBG9 0 bg9 DC 2.5000000000e-6
QG9 cg9 bg9 0 OC_KEC-SEMICON_2N3904S-RTK-PS
VCG10 cg10 0 DC 1.0000000000e0
IBG10 0 bg10 DC 1.4285714286e-5
QG10 cg10 bg10 0 OC_KEC-SEMICON_2N3904S-RTK-PS
VCG11 cg11 0 DC 1.0000000000e0
IBG11 0 bg11 DC 1.0000000000e-4
QG11 cg11 bg11 0 OC_KEC-SEMICON_2N3904S-RTK-PS
VCG12 cg12 0 DC 1.0000000000e0
IBG12 0 bg12 DC 3.3333333333e-5
QG12 cg12 bg12 0 OC_KEC-SEMICON_2N3904S-RTK-PS
VCG13 cg13 0 DC 1.0000000000e0
IBG13 0 bg13 DC 8.3333333333e-4
QG13 cg13 bg13 0 OC_KEC-SEMICON_2N3904S-RTK-PS
VCG14 cg14 0 DC 1.0000000000e0
IBG14 0 bg14 DC 3.3333333333e-3
QG14 cg14 bg14 0 OC_KEC-SEMICON_2N3904S-RTK-PS
.op
.end
