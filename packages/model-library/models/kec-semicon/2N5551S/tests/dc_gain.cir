OpenCircuit factory test: 2N5551S-RTK-P DC gain
* OpenCircuit Model Factory v0.1.0 bulk adapter
* Original work generated from public factual specifications.
* This model is not copied or adapted from any vendor SPICE model.
* Source: https://jlcpcb.com/api/file/downloadByFileSystemAccessId/8586187533709955072
* Revision: Revision No : 3, 2016. 03. 28
.model OC_KEC-SEMICON_2N5551S-RTK-P NPN(IS=1.0000000000e-14 BF=1.4900000000e2 VAF=1.0000000000e2 IKF=1.0000000000e3 RB=1.0000000000e1 RC=1.0000000000e-1 RE=5.0000000000e-2 CJE=1.0000000000e-12 CJC=1.0000000000e-12 TF=1.0000000000e-9)

.temp 25
VCG1 cg1 0 DC 5.0000000000e0
IBG1 0 bg1 DC 1.2500000000e-5
QG1 cg1 bg1 0 OC_KEC-SEMICON_2N5551S-RTK-P
VCG2 cg2 0 DC 5.0000000000e0
IBG2 0 bg2 DC 1.2500000000e-4
QG2 cg2 bg2 0 OC_KEC-SEMICON_2N5551S-RTK-P
VCG3 cg3 0 DC 5.0000000000e0
IBG3 0 bg3 DC 1.6666666667e-3
QG3 cg3 bg3 0 OC_KEC-SEMICON_2N5551S-RTK-P
VCG4 cg4 0 DC 5.0000000000e0
IBG4 0 bg4 DC 3.4899328859e-5
QG4 cg4 bg4 0 OC_KEC-SEMICON_2N5551S-RTK-P
.op
.end
