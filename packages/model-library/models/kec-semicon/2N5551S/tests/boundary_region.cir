OpenCircuit factory test: 2N5551S-RTK-P supported-region upper-current boundary
* OpenCircuit Model Factory v0.1.0 bulk adapter
* Original work generated from public factual specifications.
* This model is not copied or adapted from any vendor SPICE model.
* Source: https://jlcpcb.com/api/file/downloadByFileSystemAccessId/8586187533709955072
* Revision: Revision No : 3, 2016. 03. 28
.model OC_KEC-SEMICON_2N5551S-RTK-P NPN(IS=1.0000000000e-14 BF=1.4900000000e2 VAF=1.0000000000e2 IKF=1.0000000000e3 RB=1.0000000000e1 RC=1.0000000000e-1 RE=5.0000000000e-2 CJE=1.0000000000e-12 CJC=1.0000000000e-12 TF=1.0000000000e-9)

.temp 25
IC 0 c DC 5.0000000000e-2
IB 0 b DC 1.6666666667e-3
Q1 c b 0 OC_KEC-SEMICON_2N5551S-RTK-P
.op
.end
