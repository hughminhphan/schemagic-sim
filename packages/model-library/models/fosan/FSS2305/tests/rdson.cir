OpenCircuit factory test: FSS2305 RDS(on)
* OpenCircuit Model Factory v0.1.0 bulk adapter
* Original work generated from public factual specifications.
* This model is not copied or adapted from any vendor SPICE model.
* Source: https://jlcpcb.com/api/file/downloadByFileSystemAccessId/8757315874435424256
* Revision: undated
.model OC_FOSAN_FSS2305 VDMOS( pchan VTO=-6.2000000000e-1 KP=4.0816326531e1 THETA=0.0000000000e0 LAMBDA=3.0000000000e-3 RD=2.6950000000e-2 RS=9.8000000000e-3 RG=1.0000000000e-4 RDS=1e9 CGS=3.7600000000e-10 CGDMAX=6.2000000000e-11 CGDMIN=6.2000000000e-11 CJO=1.4000000000e-11 IS=1.0000000000e-12 N=1.5000000000e0 RB=9.8000000000e-3)

.temp 25
M1 d1 g1 0 OC_FOSAN_FSS2305
ID1 d1 0 DC 3.4000000000e0
VG1 g1 0 DC -4.5000000000e0
.op
.end
