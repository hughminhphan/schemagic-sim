* OpenCircuit Model Factory v0.1.0 bulk adapter
* Original work generated from public factual specifications.
* This model is not copied or adapted from any vendor SPICE model.
* Source: https://jlcpcb.com/api/file/downloadByFileSystemAccessId/8603026755682639872
* Revision: revision not stated in source
.model OC_FOSAN_DSK26W D(IS=7.0405154169e-11 N=1.1000000000e0 RS=1.0000000000e-4)
