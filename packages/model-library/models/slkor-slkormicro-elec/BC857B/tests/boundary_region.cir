OpenCircuit factory test: BC857B supported-region upper-current boundary
* OpenCircuit Model Factory v0.1.0 bulk adapter
* Original work generated from public factual specifications.
* This model is not copied or adapted from any vendor SPICE model.
* Source: https://jlcpcb.com/api/file/downloadByFileSystemAccessId/8588885188210266112
* Revision: Not stated in supplied datasheet
.model OC_SLKOR-SLKORMICRO-ELEC_BC857B PNP(IS=1.0000000000e-14 BF=2.2000000000e2 VAF=1.0000000000e2 IKF=1.0000000000e3 RB=1.0000000000e1 RC=1.0000000000e-1 RE=5.0000000000e-2 CJE=1.0000000000e-12 CJC=1.0000000000e-12 TF=1.0000000000e-9)

.temp 25
IC 0 c DC -2.0000000000e-3
IB 0 b DC -9.0909090909e-6
Q1 c b 0 OC_SLKOR-SLKORMICRO-ELEC_BC857B
.op
.end
