* OpenCircuit Model Factory v0.1.0 bulk adapter
* Original work generated from public factual specifications.
* This model is not copied or adapted from any vendor SPICE model.
* Source: https://jlcpcb.com/api/file/downloadByFileSystemAccessId/8586178614127153152
* Revision: V2.0
.model OC_BL-SHANGHAI-BELLING_BLM3401 VDMOS( pchan VTO=-1.3000000000e0 KP=4.0000000000e1 THETA=0.0000000000e0 LAMBDA=3.0000000000e-3 RD=2.7500000000e-2 RS=1.0000000000e-2 RG=1.0000000000e-4 RDS=1e9 CGS=8.7500000000e-10 CGDMAX=7.5000000000e-11 CGDMIN=7.5000000000e-11 CJO=4.0000000000e-11 IS=1.0000000000e-12 N=1.5000000000e0 RB=1.0000000000e-2)
