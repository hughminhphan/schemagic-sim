OpenCircuit factory test: WST4041 RDS(on)
* OpenCircuit Model Factory v0.1.0 bulk adapter
* Original work generated from public factual specifications.
* This model is not copied or adapted from any vendor SPICE model.
* Source: https://jlcpcb.com/api/file/downloadByFileSystemAccessId/8586187748759769088
* Revision: Dec.2014
.model OC_WINSOK-SEMICON_WST4041 VDMOS( pchan VTO=-1.2000000000e0 KP=6.6666666667e1 THETA=0.0000000000e0 LAMBDA=3.0000000000e-3 RD=1.6500000000e-2 RS=6.0000000000e-3 RG=1.0000000000e-4 RDS=1e9 CGS=3.6500000000e-10 CGDMAX=5.5000000000e-11 CGDMIN=5.5000000000e-11 CJO=2.2000000000e-11 IS=1.0000000000e-12 N=1.5000000000e0 RB=6.0000000000e-3)

.temp 25
M1 d1 g1 0 OC_WINSOK-SEMICON_WST4041
ID1 d1 0 DC 3.0000000000e0
VG1 g1 0 DC -1.0000000000e1
.op
.end
