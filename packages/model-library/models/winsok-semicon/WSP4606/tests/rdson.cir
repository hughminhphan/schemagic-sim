OpenCircuit factory test: WSP4606 RDS(on)
* OpenCircuit Model Factory v0.1.0 bulk adapter
* Original work generated from public factual specifications.
* This model is not copied or adapted from any vendor SPICE model.
* Source: https://jlcpcb.com/api/file/downloadByFileSystemAccessId/8586176989716238336
* Revision: Dec.2014
.model OC_WINSOK-SEMICON_WSP4606 VDMOS( VTO=1.5000000000e0 KP=1.1111111111e2 THETA=0.0000000000e0 LAMBDA=3.0000000000e-3 RD=9.9000000000e-3 RS=3.6000000000e-3 RG=1.0000000000e-4 RDS=1e9 CGS=4.9500000000e-10 CGDMAX=5.5000000000e-11 CGDMIN=5.5000000000e-11 CJO=1.3000000000e-11 IS=1.0000000000e-12 N=1.5000000000e0 RB=3.6000000000e-3)

.temp 25
M1 d1 g1 0 OC_WINSOK-SEMICON_WSP4606
ID1 0 d1 DC 6.0000000000e0
VG1 g1 0 DC 1.0000000000e1
.op
.end
