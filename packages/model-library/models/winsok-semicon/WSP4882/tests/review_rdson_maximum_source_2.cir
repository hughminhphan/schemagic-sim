OpenCircuit independent review hard-bound probe
* OpenCircuit Model Factory v0.1.0 bulk adapter
* Original work generated from public factual specifications.
* This model is not copied or adapted from any vendor SPICE model.
* Source: https://jlcpcb.com/api/file/downloadByFileSystemAccessId/8588884332409212928
* Revision: Dec.2014
.model OC_WINSOK-SEMICON_WSP4882 VDMOS( VTO=1.8000000000e0 KP=1.0000000000e2 THETA=0.0000000000e0 LAMBDA=3.0000000000e-3 RD=1.1000000000e-2 RS=4.0000000000e-3 RG=1.0000000000e-4 RDS=1e9 CGS=5.0500000000e-10 CGDMAX=5.5000000000e-11 CGDMIN=5.5000000000e-11 CJO=3.7000000000e-11 IS=1.0000000000e-12 N=1.5000000000e0 RB=4.0000000000e-3)
.temp 25
M1 d g 0 OC_WINSOK-SEMICON_WSP4882
ID 0 d DC 8.0
VG g 0 DC 10.0
.op
.end
