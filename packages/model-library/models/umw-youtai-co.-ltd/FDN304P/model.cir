* OpenCircuit Model Factory v0.1.0 bulk adapter
* Original work generated from public factual specifications.
* This model is not copied or adapted from any vendor SPICE model.
* Source: https://jlcpcb.com/api/file/downloadByFileSystemAccessId/8755876973040013312
* Revision: Nov.2024
.model OC_UMW-YOUTAI-SEMICONDUCTOR-CO.-LTD_FDN304P-UMW VDMOS( pchan VTO=-1.5000000000e0 KP=3.8461538462e1 THETA=0.0000000000e0 LAMBDA=3.0000000000e-3 RD=2.8600000000e-2 RS=1.0400000000e-2 RG=1.0000000000e-4 RDS=1e9 CGS=1.2060000000e-9 CGDMAX=1.0600000000e-10 CGDMIN=1.0600000000e-10 CJO=1.3400000000e-10 IS=1.0000000000e-12 N=1.5000000000e0 RB=1.0400000000e-2)
