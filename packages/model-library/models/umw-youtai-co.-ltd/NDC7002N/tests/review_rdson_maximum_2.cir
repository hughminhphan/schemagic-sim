OpenCircuit independent review hard-bound probe
* OpenCircuit Model Factory v0.1.0 bulk adapter
* Original work generated from public factual specifications.
* This model is not copied or adapted from any vendor SPICE model.
* Source: https://jlcpcb.com/api/file/downloadByFileSystemAccessId/8755881186323238912
* Revision: Nov.2024
.model OC_UMW-YOUTAI-SEMICONDUCTOR-CO.-LTD_NDC7002N-UMW VDMOS( VTO=1.9000000000e0 KP=2.0000000000e0 THETA=0.0000000000e0 LAMBDA=3.0000000000e-3 RD=5.5000000000e-1 RS=2.0000000000e-1 RG=1.0000000000e-4 RDS=1e9 CGS=1.5000000000e-11 CGDMAX=5.0000000000e-12 CGDMIN=5.0000000000e-12 CJO=8.0000000000e-12 IS=1.0000000000e-12 N=1.5000000000e0 RB=2.0000000000e-1)
.temp 25
M1 d g 0 OC_UMW-YOUTAI-SEMICONDUCTOR-CO.-LTD_NDC7002N-UMW
ID 0 d DC 3.500000000000e-1
VG g 0 DC 4.500000000000e+0
.op
.end
