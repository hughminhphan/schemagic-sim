OpenCircuit factory test: BFP650H6327 supported-region upper-current boundary
* OpenCircuit Model Factory v0.1.0 bulk adapter
* Original work generated from public factual specifications.
* This model is not copied or adapted from any vendor SPICE model.
* Source: https://jlcpcb.com/api/file/downloadByFileSystemAccessId/8588894497208487936
* Revision: Revision 1.1, 2012-09-13
.model OC_INFINEON-TECHNOLOGIES_BFP650H6327 NPN(IS=1.0000000000e-14 BF=1.7000000000e2 VAF=1.0000000000e2 IKF=1.0000000000e3 RB=1.0000000000e1 RC=1.0000000000e-1 RE=5.0000000000e-2 CJE=1.0000000000e-12 CJC=1.0000000000e-12 TF=1.0000000000e-9)

.temp 25
IC 0 c DC 7.0000000000e-2
IB 0 b DC 7.0000000000e-4
Q1 c b 0 OC_INFINEON-TECHNOLOGIES_BFP650H6327
.op
.end
