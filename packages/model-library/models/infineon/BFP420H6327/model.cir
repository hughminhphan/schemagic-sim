* OpenCircuit Model Factory v0.1.0 bulk adapter
* Original work generated from public factual specifications.
* This model is not copied or adapted from any vendor SPICE model.
* Source: https://jlcpcb.com/api/file/downloadByFileSystemAccessId/8757970042510426112
* Revision: Revision 3.0, 2024-07-01
.model OC_INFINEON-TECHNOLOGIES_BFP420H6327 NPN(IS=1.0000000000e-14 BF=9.1255020447e1 VAF=1.0000000000e2 IKF=1.9697313286e-1 RB=1.0000000000e1 RC=1.0000000000e-1 RE=5.0000000000e-2 CJE=1.0000000000e-12 CJC=1.0000000000e-12 TF=1.0000000000e-9)
