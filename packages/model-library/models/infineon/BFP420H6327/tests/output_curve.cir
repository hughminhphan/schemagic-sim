OpenCircuit factory test: BFP420H6327 output sanity
* OpenCircuit Model Factory v0.1.0 bulk adapter
* Original work generated from public factual specifications.
* This model is not copied or adapted from any vendor SPICE model.
* Source: https://jlcpcb.com/api/file/downloadByFileSystemAccessId/8757970042510426112
* Revision: Revision 3.0, 2024-07-01
.model OC_INFINEON-TECHNOLOGIES_BFP420H6327 NPN(IS=1.0000000000e-14 BF=9.1255020447e1 VAF=1.0000000000e2 IKF=1.9697313286e-1 RB=1.0000000000e1 RC=1.0000000000e-1 RE=5.0000000000e-2 CJE=1.0000000000e-12 CJC=1.0000000000e-12 TF=1.0000000000e-9)

.temp 25
VCE1 c1 0 DC 2
IB1 0 b1 DC 0.00001
Q1 c1 b1 0 OC_INFINEON-TECHNOLOGIES_BFP420H6327
VCE2 c2 0 DC 10
IB2 0 b2 DC 0.00005
Q2 c2 b2 0 OC_INFINEON-TECHNOLOGIES_BFP420H6327
.op
.end
