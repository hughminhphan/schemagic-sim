Batch 9 independent review: BFP420H6327 exact gain hard bounds
* Public datasheet facts only; no vendor SPICE model used.
.model OC_INFINEON-TECHNOLOGIES_BFP420H6327 NPN(IS=1.0000000000e-14 BF=9.1255020447e1 VAF=1.0000000000e2 IKF=1.9697313286e-1 RB=1.0000000000e1 RC=1.0000000000e-1 RE=5.0000000000e-2 CJE=1.0000000000e-12 CJC=1.0000000000e-12 TF=1.0000000000e-9)

.temp 25
VCG1 cg1 0 DC 4
IBG1 0 bg1 DC 0.0002331177995954984
QG1 cg1 bg1 0 OC_INFINEON-TECHNOLOGIES_BFP420H6327
.op
.end
