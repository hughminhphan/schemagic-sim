OpenCircuit factory test: BFP420H6327 DC gain
* OpenCircuit Model Factory v0.1.0 bulk adapter
* Original work generated from public factual specifications.
* This model is not copied or adapted from any vendor SPICE model.
* Source: https://jlcpcb.com/api/file/downloadByFileSystemAccessId/8757970042510426112
* Revision: Revision 3.0, 2024-07-01
.model OC_INFINEON-TECHNOLOGIES_BFP420H6327 NPN(IS=1.0000000000e-14 BF=9.1255020447e1 VAF=1.0000000000e2 IKF=1.9697313286e-1 RB=1.0000000000e1 RC=1.0000000000e-1 RE=5.0000000000e-2 CJE=1.0000000000e-12 CJC=1.0000000000e-12 TF=1.0000000000e-9)

.temp 25
VCG1 cg1 0 DC 3.0000000000e0
IBG1 0 bg1 DC 1.0526315789e-6
QG1 cg1 bg1 0 OC_INFINEON-TECHNOLOGIES_BFP420H6327
VCG2 cg2 0 DC 3.0000000000e0
IBG2 0 bg2 DC 1.0869565217e-5
QG2 cg2 bg2 0 OC_INFINEON-TECHNOLOGIES_BFP420H6327
VCG3 cg3 0 DC 3.0000000000e0
IBG3 0 bg3 DC 1.1363636364e-4
QG3 cg3 bg3 0 OC_INFINEON-TECHNOLOGIES_BFP420H6327
VCG4 cg4 0 DC 3.0000000000e0
IBG4 0 bg4 DC 6.6666666667e-4
QG4 cg4 bg4 0 OC_INFINEON-TECHNOLOGIES_BFP420H6327
VCG5 cg5 0 DC 4.0000000000e0
IBG5 0 bg5 DC 3.3333333333e-4
QG5 cg5 bg5 0 OC_INFINEON-TECHNOLOGIES_BFP420H6327
VCG6 cg6 0 DC 4.0000000000e0
IBG6 0 bg6 DC 2.1052631579e-4
QG6 cg6 bg6 0 OC_INFINEON-TECHNOLOGIES_BFP420H6327
VCG7 cg7 0 DC 4.0000000000e0
IBG7 0 bg7 DC 1.5384615385e-4
QG7 cg7 bg7 0 OC_INFINEON-TECHNOLOGIES_BFP420H6327
.op
.end
