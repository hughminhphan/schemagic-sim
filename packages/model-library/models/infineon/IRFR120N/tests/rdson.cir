OpenCircuit factory test: IRFR120NTRPBF RDS(on)
* OpenCircuit Model Factory v0.1.0 bulk adapter
* Original work generated from public factual specifications.
* This model is not copied or adapted from any vendor SPICE model.
* Source: https://jlcpcb.com/api/file/downloadByFileSystemAccessId/8579711221681356801
* Revision: PD-95067A, 12/9/04
.model OC_INFINEON-TECHNOLOGIES_IRFR120NTRPBF VDMOS( VTO=4.0000000000e0 KP=1.0582010582e1 THETA=0.0000000000e0 LAMBDA=3.0000000000e-3 RD=1.0395000000e-1 RS=3.7800000000e-2 RG=1.0000000000e-4 RDS=1e9 CGS=2.7600000000e-10 CGDMAX=5.4000000000e-11 CGDMIN=5.4000000000e-11 CJO=3.8000000000e-11 IS=1.0000000000e-12 N=1.5000000000e0 RB=3.7800000000e-2)

.temp 25
M1 d1 g1 0 OC_INFINEON-TECHNOLOGIES_IRFR120NTRPBF
ID1 0 d1 DC 5.6000000000e0
VG1 g1 0 DC 1.0000000000e1
.op
.end
