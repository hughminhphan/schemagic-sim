OpenCircuit factory test: IRF3710PBF RDS(on)
* OpenCircuit Model Factory v0.1.0 bulk adapter
* Original work generated from public factual specifications.
* This model is not copied or adapted from any vendor SPICE model.
* Source: https://jlcpcb.com/api/file/downloadByFileSystemAccessId/8588896295771639808
* Revision: PD-94954D, 23-Jul-2010
.model OC_INFINEON-TECHNOLOGIES_IRF3710PBF VDMOS( VTO=4.0000000000e0 KP=9.6618357488e1 THETA=0.0000000000e0 LAMBDA=3.0000000000e-3 RD=1.1385000000e-2 RS=4.1400000000e-3 RG=1.0000000000e-4 RDS=1e9 CGS=3.0580000000e-9 CGDMAX=7.2000000000e-11 CGDMIN=7.2000000000e-11 CJO=3.3800000000e-10 IS=1.0000000000e-12 N=1.5000000000e0 RB=4.1400000000e-3)

.temp 25
M1 d1 g1 0 OC_INFINEON-TECHNOLOGIES_IRF3710PBF
ID1 0 d1 DC 2.8000000000e1
VG1 g1 0 DC 1.0000000000e1
.op
.end
