* OpenCircuit Model Factory v0.1.0 bulk adapter
* Original work generated from public factual specifications.
* This model is not copied or adapted from any vendor SPICE model.
* Source: https://jlcpcb.com/api/file/downloadByFileSystemAccessId/8588885320984748032
* Revision: PD-97146A, 11/23/09
.model OC_INFINEON-TECHNOLOGIES_IRLR8726TRPBF VDMOS( VTO=1.8000000000e0 KP=5.0000000000e2 THETA=0.0000000000e0 LAMBDA=3.0000000000e-3 RD=2.2000000000e-3 RS=8.0000000000e-4 RG=1.0000000000e-4 RDS=1e9 CGS=1.9450000000e-9 CGDMAX=2.0500000000e-10 CGDMIN=2.0500000000e-10 CJO=2.7500000000e-10 IS=1.0000000000e-12 N=1.5000000000e0 RB=8.0000000000e-4)
