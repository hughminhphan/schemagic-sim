OpenCircuit factory test: IRF530NPBF RDS(on)
* OpenCircuit Model Factory v0.1.0 bulk adapter
* Original work generated from public factual specifications.
* This model is not copied or adapted from any vendor SPICE model.
* Source: https://jlcpcb.com/api/file/downloadByFileSystemAccessId/8588887091854397440
* Revision: PD-94962; 01/30/04
.model OC_INFINEON-TECHNOLOGIES_IRF530NPBF VDMOS( VTO=4.0000000000e0 KP=2.4691358025e1 THETA=0.0000000000e0 LAMBDA=3.0000000000e-3 RD=4.4550000000e-2 RS=1.6200000000e-2 RG=1.0000000000e-4 RDS=1e9 CGS=9.0100000000e-10 CGDMAX=1.9000000000e-11 CGDMIN=1.9000000000e-11 CJO=1.1100000000e-10 IS=1.0000000000e-12 N=1.5000000000e0 RB=1.6200000000e-2)

.temp 25
M1 d1 g1 0 OC_INFINEON-TECHNOLOGIES_IRF530NPBF
ID1 0 d1 DC 9.0000000000e0
VG1 g1 0 DC 1.0000000000e1
.op
.end
