OpenCircuit independent review hard-bound probe
* OpenCircuit Model Factory v0.1.0 bulk adapter
* Original work generated from public factual specifications.
* This model is not copied or adapted from any vendor SPICE model.
* Source: https://jlcpcb.com/api/file/downloadByFileSystemAccessId/8586187717328195584
* Revision: Rev 2.7, 2011-07-11
.model OC_INFINEON-TECHNOLOGIES_BSS84PH6327 VDMOS( pchan VTO=-1.5000000000e0 KP=2.5000000000e-1 THETA=0.0000000000e0 LAMBDA=3.0000000000e-3 RD=4.4000000000e0 RS=1.6000000000e0 RG=1.0000000000e-4 RDS=1e9 CGS=1.3000000000e-11 CGDMAX=2.0000000000e-12 CGDMIN=2.0000000000e-12 CJO=4.0000000000e-12 IS=1.0000000000e-12 N=1.5000000000e0 RB=1.6000000000e0)
.temp 25
M1 d g 0 OC_INFINEON-TECHNOLOGIES_BSS84PH6327
ID d 0 DC 1.400000000000e-1
VG g 0 DC -4.500000000000e+0
.op
.end
