OpenCircuit factory test: IRFP260MPBF RDS(on)
* OpenCircuit Model Factory v0.1.0 bulk adapter
* Original work generated from public factual specifications.
* This model is not copied or adapted from any vendor SPICE model.
* Source: https://jlcpcb.com/api/file/downloadByFileSystemAccessId/8588887162099654656
* Revision: PD-96293; 03/01/10
.model OC_INFINEON-TECHNOLOGIES_IRFP260MPBF VDMOS( VTO=4.0000000000e0 KP=5.5555555556e1 THETA=0.0000000000e0 LAMBDA=3.0000000000e-3 RD=1.9800000000e-2 RS=7.2000000000e-3 RG=1.0000000000e-4 RDS=1e9 CGS=3.8960000000e-9 CGDMAX=1.6100000000e-10 CGDMIN=1.6100000000e-10 CJO=4.4200000000e-10 IS=1.0000000000e-12 N=1.5000000000e0 RB=7.2000000000e-3)

.temp 25
M1 d1 g1 0 OC_INFINEON-TECHNOLOGIES_IRFP260MPBF
ID1 0 d1 DC 2.8000000000e1
VG1 g1 0 DC 1.0000000000e1
.op
.end
