OpenCircuit factory test: IRFP064NPBF RDS(on)
* OpenCircuit Model Factory v0.1.0 bulk adapter
* Original work generated from public factual specifications.
* This model is not copied or adapted from any vendor SPICE model.
* Source: https://jlcpcb.com/api/file/downloadByFileSystemAccessId/8588887164121714688
* Revision: PD-95001, dated 02/11/04
.model OC_INFINEON-TECHNOLOGIES_IRFP064NPBF VDMOS( VTO=4.0000000000e0 KP=2.7777777778e2 THETA=0.0000000000e0 LAMBDA=3.0000000000e-3 RD=3.9600000000e-3 RS=1.4400000000e-3 RG=1.0000000000e-4 RDS=1e9 CGS=3.5200000000e-9 CGDMAX=4.8000000000e-10 CGDMIN=4.8000000000e-10 CJO=8.2000000000e-10 IS=1.0000000000e-12 N=1.5000000000e0 RB=1.4400000000e-3)

.temp 25
M1 d1 g1 0 OC_INFINEON-TECHNOLOGIES_IRFP064NPBF
ID1 0 d1 DC 5.9000000000e1
VG1 g1 0 DC 1.0000000000e1
.op
.end
