* OpenCircuit Model Factory v0.1.0 bulk adapter
* Original work generated from public factual specifications.
* This model is not copied or adapted from any vendor SPICE model.
* Source: https://jlcpcb.com/api/file/downloadByFileSystemAccessId/8588954671637938176
* Revision: Rev. 1.6, 2014-07-07
.model OC_INFINEON-TECHNOLOGIES_BSS83PH6327 VDMOS( pchan VTO=-1.8278034169e0 KP=5.2882014967e-1 THETA=7.5265926856e-2 LAMBDA=1.5171612683e-12 RD=3.7967782447e-1 RS=4.0000000000e-1 RG=1.0000000000e-4 RDS=1e9 CGS=5.5000000000e-11 CGDMAX=7.0000000000e-12 CGDMIN=7.0000000000e-12 CJO=1.2000000000e-11 IS=1.0000000000e-12 N=1.5000000000e0 RB=4.0000000000e-1)
