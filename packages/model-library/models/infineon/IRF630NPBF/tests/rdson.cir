OpenCircuit factory test: IRF630NPBF RDS(on)
* OpenCircuit Model Factory v0.1.0 bulk adapter
* Original work generated from public factual specifications.
* This model is not copied or adapted from any vendor SPICE model.
* Source: https://jlcpcb.com/api/file/downloadByFileSystemAccessId/8588887159567106048
* Revision: PD-95047A, 07/23/10
.model OC_INFINEON-TECHNOLOGIES_IRF630NPBF VDMOS( VTO=4.0000000000e0 KP=7.4074074074e0 THETA=0.0000000000e0 LAMBDA=3.0000000000e-3 RD=1.4850000000e-1 RS=5.4000000000e-2 RG=1.0000000000e-4 RDS=1e9 CGS=5.5000000000e-10 CGDMAX=2.5000000000e-11 CGDMIN=2.5000000000e-11 CJO=6.4000000000e-11 IS=1.0000000000e-12 N=1.5000000000e0 RB=5.4000000000e-2)

.temp 25
M1 d1 g1 0 OC_INFINEON-TECHNOLOGIES_IRF630NPBF
ID1 0 d1 DC 5.4000000000e0
VG1 g1 0 DC 1.0000000000e1
.op
.end
