* OpenCircuit Model Factory v0.1.0 bulk adapter
* Original work generated from public factual specifications.
* This model is not copied or adapted from any vendor SPICE model.
* Source: https://jlcpcb.com/api/file/downloadByFileSystemAccessId/8588886840707321856
* Revision: Rev. 2.2, 2016-10-13
.model OC_INFINEON-TECHNOLOGIES_IPT015N10N5 VDMOS( VTO=3.0000000000e0 KP=1.5384615385e3 THETA=0.0000000000e0 LAMBDA=3.0000000000e-3 RD=7.1500000000e-4 RS=2.6000000000e-4 RG=1.0000000000e-4 RDS=1e9 CGS=1.1920000000e-8 CGDMAX=8.0000000000e-11 CGDMIN=8.0000000000e-11 CJO=1.7200000000e-9 IS=1.0000000000e-12 N=1.5000000000e0 RB=2.6000000000e-4)
