OpenCircuit factory test: IRLML6344TRPBF RDS(on)
* OpenCircuit Model Factory v0.1.0 bulk adapter
* Original work generated from public factual specifications.
* This model is not copied or adapted from any vendor SPICE model.
* Source: https://jlcpcb.com/api/file/downloadByFileSystemAccessId/8586179582030991360
* Revision: December 19, 2014
.model OC_INFINEON-TECHNOLOGIES_IRLML6344TRPBF VDMOS( VTO=8.0000000000e-1 KP=9.0909090909e1 THETA=0.0000000000e0 LAMBDA=3.0000000000e-3 RD=1.2100000000e-2 RS=4.4000000000e-3 RG=1.0000000000e-4 RDS=1e9 CGS=6.0400000000e-10 CGDMAX=4.6000000000e-11 CGDMIN=4.6000000000e-11 CJO=1.9000000000e-11 IS=1.0000000000e-12 N=1.5000000000e0 RB=4.4000000000e-3)

.temp 25
M1 d1 g1 0 OC_INFINEON-TECHNOLOGIES_IRLML6344TRPBF
ID1 0 d1 DC 5.0000000000e0
VG1 g1 0 DC 4.5000000000e0
.op
.end
