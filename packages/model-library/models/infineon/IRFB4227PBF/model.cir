* OpenCircuit Model Factory v0.1.0 bulk adapter
* Original work generated from public factual specifications.
* This model is not copied or adapted from any vendor SPICE model.
* Source: https://jlcpcb.com/api/file/downloadByFileSystemAccessId/8588887123156353024
* Revision: 09/10/07
.model OC_INFINEON-TECHNOLOGIES_IRFB4227PBF VDMOS( VTO=5.0000000000e0 KP=1.0152284264e2 THETA=0.0000000000e0 LAMBDA=3.0000000000e-3 RD=1.0835000000e-2 RS=3.9400000000e-3 RG=1.0000000000e-4 RDS=1e9 CGS=4.5090000000e-9 CGDMAX=9.1000000000e-11 CGDMIN=9.1000000000e-11 CJO=3.6900000000e-10 IS=1.0000000000e-12 N=1.5000000000e0 RB=3.9400000000e-3)
