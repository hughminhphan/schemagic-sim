OpenCircuit independent review hard-bound probe
* OpenCircuit Model Factory v0.1.0 bulk adapter
* Original work generated from public factual specifications.
* This model is not copied or adapted from any vendor SPICE model.
* Source: https://jlcpcb.com/api/file/downloadByFileSystemAccessId/8588880657325547520
* Revision: PD-97432, 11/4/09
.model OC_INFINEON-TECHNOLOGIES_IRLML2030TRPBF VDMOS( VTO=1.7000000000e0 KP=1.6260162602e1 THETA=0.0000000000e0 LAMBDA=3.0000000000e-3 RD=6.7650000000e-2 RS=2.4600000000e-2 RG=1.0000000000e-4 RDS=1e9 CGS=9.8000000000e-11 CGDMAX=1.2000000000e-11 CGDMIN=1.2000000000e-11 CJO=1.7000000000e-11 IS=1.0000000000e-12 N=1.5000000000e0 RB=2.4600000000e-2)
.temp 25
M1 d g 0 OC_INFINEON-TECHNOLOGIES_IRLML2030TRPBF
ID 0 d DC 2.700000000000e+0
VG g 0 DC 1.000000000000e+1
.op
.end
