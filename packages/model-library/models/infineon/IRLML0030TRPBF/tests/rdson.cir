OpenCircuit factory test: IRLML0030TRPBF RDS(on)
* OpenCircuit Model Factory v0.1.0 bulk adapter
* Original work generated from public factual specifications.
* This model is not copied or adapted from any vendor SPICE model.
* Source: https://jlcpcb.com/api/file/downloadByFileSystemAccessId/8586186967407071232
* Revision: PD-96278B, 02/29/12
.model OC_INFINEON-TECHNOLOGIES_IRLML0030TRPBF VDMOS( VTO=1.7000000000e0 KP=6.0606060606e1 THETA=0.0000000000e0 LAMBDA=3.0000000000e-3 RD=1.8150000000e-2 RS=6.6000000000e-3 RG=1.0000000000e-4 RDS=1e9 CGS=3.4300000000e-10 CGDMAX=3.9000000000e-11 CGDMIN=3.9000000000e-11 CJO=4.5000000000e-11 IS=1.0000000000e-12 N=1.5000000000e0 RB=6.6000000000e-3)

.temp 25
M1 d1 g1 0 OC_INFINEON-TECHNOLOGIES_IRLML0030TRPBF
ID1 0 d1 DC 4.2000000000e0
VG1 g1 0 DC 4.5000000000e0
.op
.end
