* OpenCircuit Model Factory v0.1.0 bulk adapter
* Original work generated from public factual specifications.
* This model is not copied or adapted from any vendor SPICE model.
* Source: https://jlcpcb.com/api/file/downloadByFileSystemAccessId/8579710818147094528
* Revision: PD-95066A, 12/14/04
.model OC_INFINEON-TECHNOLOGIES_IRFR024NTRPBF VDMOS( VTO=4.0000000000e0 KP=2.9629629630e1 THETA=0.0000000000e0 LAMBDA=3.0000000000e-3 RD=3.7125000000e-2 RS=1.3500000000e-2 RG=1.0000000000e-4 RDS=1e9 CGS=3.0500000000e-10 CGDMAX=6.5000000000e-11 CGDMIN=6.5000000000e-11 CJO=7.5000000000e-11 IS=1.0000000000e-12 N=1.5000000000e0 RB=1.3500000000e-2)
