* OpenCircuit Model Factory v0.1.0 bulk adapter
* Original work generated from public factual specifications.
* This model is not copied or adapted from any vendor SPICE model.
* Source: https://jlcpcb.com/api/file/downloadByFileSystemAccessId/8588887159570894848
* Revision: 8/27/97
.model OC_INFINEON-TECHNOLOGIES_IRF9Z24NPBF VDMOS( pchan VTO=-4.0000000000e0 KP=1.2698412698e1 THETA=0.0000000000e0 LAMBDA=3.0000000000e-3 RD=8.6625000000e-2 RS=3.1500000000e-2 RG=1.0000000000e-4 RDS=1e9 CGS=2.5800000000e-10 CGDMAX=9.2000000000e-11 CGDMIN=9.2000000000e-11 CJO=7.8000000000e-11 IS=1.0000000000e-12 N=1.5000000000e0 RB=3.1500000000e-2)
