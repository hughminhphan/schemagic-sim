OpenCircuit factory test: AO3400-ED RDS(on)
* OpenCircuit Model Factory v0.1.0 bulk adapter
* Original work generated from public factual specifications.
* This model is not copied or adapted from any vendor SPICE model.
* Source: https://jlcpcb.com/api/file/downloadByFileSystemAccessId/8589835429052133376
* Revision: Not stated in datasheet
.model OC_HXY-MOSFET_AO3400-ED VDMOS( VTO=7.5000000000e-1 KP=3.2258064516e1 THETA=0.0000000000e0 LAMBDA=3.0000000000e-3 RD=3.4100000000e-2 RS=1.2400000000e-2 RG=1.0000000000e-4 RDS=1e9 CGS=2.3300000000e-10 CGDMAX=2.7000000000e-11 CGDMIN=2.7000000000e-11 CJO=2.1000000000e-11 IS=1.0000000000e-12 N=1.5000000000e0 RB=1.2400000000e-2)

.temp 25
M1 d1 g1 0 OC_HXY-MOSFET_AO3400-ED
ID1 0 d1 DC 2.0000000000e0
VG1 g1 0 DC 2.5000000000e0
M2 d2 g2 0 OC_HXY-MOSFET_AO3400-ED
ID2 0 d2 DC 2.0000000000e0
VG2 g2 0 DC 2.5000000000e0
M3 d3 g3 0 OC_HXY-MOSFET_AO3400-ED
ID3 0 d3 DC 2.8000000000e0
VG3 g3 0 DC 4.5000000000e0
M4 d4 g4 0 OC_HXY-MOSFET_AO3400-ED
ID4 0 d4 DC 2.8000000000e0
VG4 g4 0 DC 4.5000000000e0
.op
.end
