OpenCircuit independent review hard-bound probe
* OpenCircuit Model Factory v0.1.0 bulk adapter
* Original work generated from public factual specifications.
* This model is not copied or adapted from any vendor SPICE model.
* Source: https://jlcpcb.com/api/file/downloadByFileSystemAccessId/8590905232459452416
* Revision: Public datasheet, revision not stated
.model OC_HXY-MOSFET_SI2319 VDMOS( pchan VTO=-1.9000000000e0 KP=2.6143790850e1 THETA=0.0000000000e0 LAMBDA=3.0000000000e-3 RD=4.2075000000e-2 RS=1.5300000000e-2 RG=1.0000000000e-4 RDS=1e9 CGS=5.3000000000e-10 CGDMAX=7.0000000000e-11 CGDMIN=7.0000000000e-11 CJO=2.0000000000e-11 IS=1.0000000000e-12 N=1.5000000000e0 RB=1.5300000000e-2)
.temp 25
M1 d g 0 OC_HXY-MOSFET_SI2319
ID d 0 DC 2.000000000000e+0
VG g 0 DC -4.500000000000e+0
.op
.end
