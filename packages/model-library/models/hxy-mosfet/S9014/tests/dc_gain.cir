OpenCircuit factory test: S9014 DC gain
* OpenCircuit Model Factory v0.1.0 bulk adapter
* Original work generated from public factual specifications.
* This model is not copied or adapted from any vendor SPICE model.
* Source: https://jlcpcb.com/api/file/downloadByFileSystemAccessId/8590440689554395136
* Revision: Not stated
.model OC_HXY-MOSFET_S9014 NPN(IS=1.0000000000e-14 BF=3.4823410333e2 VAF=1.0000000000e2 IKF=1.3957935056e-1 ISE=3.6969202544e-14 NE=1.5000000000e0 NF=1.0000000000e0 RB=1.0000000000e1 RC=1.0000000000e-1 RE=5.0000000000e-2 CJE=1.0000000000e-12 CJC=1.0000000000e-12 TF=1.0000000000e-9)

.temp 25
VCG1 cg1 0 DC 5.0000000000e0
IBG1 0 bg1 DC 4.3478260870e-7
QG1 cg1 bg1 0 OC_HXY-MOSFET_S9014
VCG2 cg2 0 DC 5.0000000000e0
IBG2 0 bg2 DC 3.7037037037e-6
QG2 cg2 bg2 0 OC_HXY-MOSFET_S9014
VCG3 cg3 0 DC 5.0000000000e0
IBG3 0 bg3 DC 3.3333333333e-5
QG3 cg3 bg3 0 OC_HXY-MOSFET_S9014
VCG4 cg4 0 DC 5.0000000000e0
IBG4 0 bg4 DC 1.7857142857e-4
QG4 cg4 bg4 0 OC_HXY-MOSFET_S9014
VCG5 cg5 0 DC 5.0000000000e0
IBG5 0 bg5 DC 5.2631578947e-4
QG5 cg5 bg5 0 OC_HXY-MOSFET_S9014
VCG6 cg6 0 DC 5.0000000000e0
IBG6 0 bg6 DC 5.0000000000e-6
QG6 cg6 bg6 0 OC_HXY-MOSFET_S9014
.op
.end
