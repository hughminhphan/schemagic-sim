OpenCircuit factory test: S9014 supported-region upper-current boundary
* OpenCircuit Model Factory v0.1.0 bulk adapter
* Original work generated from public factual specifications.
* This model is not copied or adapted from any vendor SPICE model.
* Source: https://jlcpcb.com/api/file/downloadByFileSystemAccessId/8590440689554395136
* Revision: Not stated
.model OC_HXY-MOSFET_S9014 NPN(IS=1.0000000000e-14 BF=3.4823410333e2 VAF=1.0000000000e2 IKF=1.3957935056e-1 ISE=3.6969202544e-14 NE=1.5000000000e0 NF=1.0000000000e0 RB=1.0000000000e1 RC=1.0000000000e-1 RE=5.0000000000e-2 CJE=1.0000000000e-12 CJC=1.0000000000e-12 TF=1.0000000000e-9)

.temp 25
IC 0 c DC 1.0000000000e-1
IB 0 b DC 5.2631578947e-4
Q1 c b 0 OC_HXY-MOSFET_S9014
.op
.end
