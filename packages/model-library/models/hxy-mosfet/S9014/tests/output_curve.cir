OpenCircuit factory test: S9014 output sanity
* OpenCircuit Model Factory v0.1.0 bulk adapter
* Original work generated from public factual specifications.
* This model is not copied or adapted from any vendor SPICE model.
* Source: https://jlcpcb.com/api/file/downloadByFileSystemAccessId/8590440689554395136
* Revision: Not stated
.model OC_HXY-MOSFET_S9014 NPN(IS=1.0000000000e-14 BF=3.4823410333e2 VAF=1.0000000000e2 IKF=1.3957935056e-1 ISE=3.6969202544e-14 NE=1.5000000000e0 NF=1.0000000000e0 RB=1.0000000000e1 RC=1.0000000000e-1 RE=5.0000000000e-2 CJE=1.0000000000e-12 CJC=1.0000000000e-12 TF=1.0000000000e-9)

.temp 25
VCE1 c1 0 DC 2
IB1 0 b1 DC 0.00001
Q1 c1 b1 0 OC_HXY-MOSFET_S9014
VCE2 c2 0 DC 10
IB2 0 b2 DC 0.00005
Q2 c2 b2 0 OC_HXY-MOSFET_S9014
.op
.end
