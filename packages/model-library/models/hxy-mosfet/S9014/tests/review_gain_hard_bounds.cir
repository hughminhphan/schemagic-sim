Batch 9 independent review: S9014 exact gain hard bounds
* Public datasheet facts only; no vendor SPICE model used.
.model OC_HXY-MOSFET_S9014 NPN(IS=1.0000000000e-14 BF=3.4823410333e2 VAF=1.0000000000e2 IKF=1.3957935056e-1 ISE=3.6969202544e-14 NE=1.5000000000e0 NF=1.0000000000e0 RB=1.0000000000e1 RC=1.0000000000e-1 RE=5.0000000000e-2 CJE=1.0000000000e-12 CJC=1.0000000000e-12 TF=1.0000000000e-9)

.temp 25
VCG1 cg1 0 DC 5
IBG1 0 bg1 DC 3.5487888525801528e-06
QG1 cg1 bg1 0 OC_HXY-MOSFET_S9014
.op
.end
