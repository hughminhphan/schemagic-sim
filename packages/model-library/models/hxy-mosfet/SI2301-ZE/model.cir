* OpenCircuit Model Factory v0.1.0 bulk adapter
* Original work generated from public factual specifications.
* This model is not copied or adapted from any vendor SPICE model.
* Source: https://jlcpcb.com/api/file/downloadByFileSystemAccessId/8554674901432442880
* Revision: not stated in datasheet
.model OC_HXY-MOSFET_SI2301-ZE VDMOS( pchan VTO=-7.0000000000e-1 KP=1.6666666667e1 THETA=0.0000000000e0 LAMBDA=3.0000000000e-3 RD=6.6000000000e-2 RS=2.4000000000e-2 RG=1.0000000000e-4 RDS=1e9 CGS=2.5300000000e-10 CGDMAX=3.2000000000e-11 CGDMIN=3.2000000000e-11 CJO=2.6000000000e-11 IS=1.0000000000e-12 N=1.5000000000e0 RB=2.4000000000e-2)
