OpenCircuit factory test: forward_10.cir
* OpenCircuit Model Factory v0.1.0 bulk adapter
* Original work generated from public factual specifications.
* This model is not copied or adapted from any vendor SPICE model.
* Source: https://jlcpcb.com/api/file/downloadByFileSystemAccessId/8590905485262872576
* Revision: Not stated in datasheet
.model OC_HXY-MOSFET_ZMM3V6 D(IS=7.9882058475e-14 N=1.0561621329e0 RS=1.2614710370e0 BV=3.6000000000e0 IBV=5.0000000000e-3 NBV=1.0000000000e0)

.temp 25
Itest 0 anode DC 1.0000000000e-3
Vanchor anchor 0 DC 0
Ranchor anchor 0 1G
Ddut anode 0 OC_HXY-MOSFET_ZMM3V6
.op
.end
