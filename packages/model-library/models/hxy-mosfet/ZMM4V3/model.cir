* OpenCircuit Model Factory v0.1.0 bulk adapter
* Original work generated from public factual specifications.
* This model is not copied or adapted from any vendor SPICE model.
* Source: https://jlcpcb.com/api/file/downloadByFileSystemAccessId/8590905684349165568
* Revision: revision not stated in source
.model OC_HXY-MOSFET_ZMM4V3 D(IS=7.3910322788e-11 N=1.8000000000e0 RS=1.0000000000e-4 BV=4.3000000000e0 IBV=5.0000000000e-3 NBV=1.0000000000e0)
