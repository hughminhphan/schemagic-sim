* OpenCircuit Model Factory v0.1.0 bulk adapter
* Original work generated from public factual specifications.
* This model is not copied or adapted from any vendor SPICE model.
* Source: https://jlcpcb.com/api/file/downloadByFileSystemAccessId/8588911510403473408
* Revision: DocID024551 Rev 6, August 2017
.model OC_STMICROELECTRONICS_STL90N10F7 VDMOS( VTO=3.5000000000e0 KP=2.8571428571e2 THETA=0.0000000000e0 LAMBDA=3.0000000000e-3 RD=3.8500000000e-3 RS=1.4000000000e-3 RG=1.0000000000e-4 RDS=1e9 CGS=3.0550000000e-9 CGDMAX=4.5000000000e-11 CGDMIN=4.5000000000e-11 CJO=6.5500000000e-10 IS=1.0000000000e-12 N=1.5000000000e0 RB=1.4000000000e-3)
