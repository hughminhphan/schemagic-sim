* BAT41 forward boundary at 0.010000000000000002 A
* OpenCircuit Model Factory v0.1.0
* Original work generated from public factual specifications.
* BAT41 (st), official product specification fallback, fitted 2026-08-07
* Archetype: archetype-diode.md, variant K
* Node order: D<ref> anode cathode OC_ST_BAT41
* Official datasheet PDF and product page were unreachable; F1 fallback uses one-sided published MAX bounds.
.model OC_ST_BAT41 D(IS=1.0000000000e-06 N=1.2000000000e00 RS=1.5000000000e00)
.temp 25
Itest 0 anode DC 1.0000000000e-02
Vanchor anchor 0 DC 0
Ranchor anchor 0 1G
Ddut anode 0 OC_ST_BAT41
.op
.end
