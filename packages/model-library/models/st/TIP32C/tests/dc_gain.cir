TIP32C DC gain hard bounds
* OpenCircuit Model Factory v0.1.0
* Original work generated from public factual specifications.
* This model is not a copy of, or adaptation from, any vendor SPICE model.
* Source: https://www.st.com/en/power-transistors/tip32c.html
* Revision: Rev. 2, November 2006
* F1 table-constrained power BJT; TNOM=27, benches set .temp 25
* Node order: collector base emitter
.model OC_ST_TIP32C PNP(IS=2.0000000000e-12 NF=1.0000000000e+00 BF=8.5000000000e+01 IKF=1.2000000000e+00 ISE=2.0000000000e-10 NE=1.5000000000e+00 VAF=6.0000000000e+01 BR=2.0000000000e+00 RB=1.0000000000e+00 RE=2.0000000000e-02 RC=6.0000000000e-02 CJE=1.0000000000e-09 VJE=7.5000000000e-01 MJE=3.3000000000e-01 CJC=3.0000000000e-10 VJC=7.5000000000e-01 MJC=3.3000000000e-01 XCJC=1.0000000000e+00 TF=5.0000000000e-08 TR=5.0000000000e-07 FC=0.5 EG=1.11 XTI=3 TNOM=27)
.temp 25
VC1 c1 0 DC -4
IB1 0 b1 DC -0.04
Q1 c1 b1 0 OC_ST_TIP32C
VC2 c2 0 DC -4
IB2 0 b2 DC -0.3
Q2 c2 b2 0 OC_ST_TIP32C
.op
.end
