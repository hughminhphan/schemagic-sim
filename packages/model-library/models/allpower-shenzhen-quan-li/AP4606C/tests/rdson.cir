OpenCircuit factory test: AP4606C RDS(on)
* OpenCircuit Model Factory v0.1.0 bulk adapter
* Original work generated from public factual specifications.
* This model is not copied or adapted from any vendor SPICE model.
* Source: https://jlcpcb.com/api/file/downloadByFileSystemAccessId/8588944924842053632
* Revision: v1.0
.model OC_ALLPOWER-SHENZHEN-QUAN-LI-SEMICONDUCTOR_AP4606C VDMOS( VTO=7.0000000000e-1 KP=9.0909090909e1 THETA=0.0000000000e0 LAMBDA=3.0000000000e-3 RD=1.2100000000e-2 RS=4.4000000000e-3 RG=1.0000000000e-4 RDS=1e9 CGS=5.6000000000e-10 CGDMAX=8.0000000000e-11 CGDMIN=8.0000000000e-11 CJO=6.0000000000e-11 IS=1.0000000000e-12 N=1.5000000000e0 RB=4.4000000000e-3)

.temp 25
M1 d1 g1 0 OC_ALLPOWER-SHENZHEN-QUAN-LI-SEMICONDUCTOR_AP4606C
ID1 0 d1 DC 6.0000000000e0
VG1 g1 0 DC 4.5000000000e0
.op
.end
