* OpenCircuit Model Factory v0.1.0 bulk adapter
* Original work generated from public factual specifications.
* This model is not copied or adapted from any vendor SPICE model.
* Source: https://jlcpcb.com/api/file/downloadByFileSystemAccessId/8588945170758832128
* Revision: V1.0
.model OC_ALLPOWER-SHENZHEN-QUAN-LI-SEMICONDUCTOR_APG077N01G VDMOS( VTO=2.0000000000e0 KP=3.2258064516e2 THETA=0.0000000000e0 LAMBDA=3.0000000000e-3 RD=3.4100000000e-3 RS=1.2400000000e-3 RG=1.0000000000e-4 RDS=1e9 CGS=2.9890000000e-9 CGDMAX=1.1000000000e-11 CGDMIN=1.1000000000e-11 CJO=3.5100000000e-10 IS=1.0000000000e-12 N=1.5000000000e0 RB=1.2400000000e-3)
