* OpenCircuit Model Factory v0.1.0 bulk adapter
* Original work generated from public factual specifications.
* This model is not copied or adapted from any vendor SPICE model.
* Source: https://jlcpcb.com/api/file/downloadByFileSystemAccessId/8588920801022525440
* Revision: v1.0
.model OC_ALLPOWER-SHENZHEN-QUAN-LI-SEMICONDUCTOR_AP30P30Q VDMOS( pchan VTO=-2.0000000000e0 KP=2.0000000000e2 THETA=0.0000000000e0 LAMBDA=3.0000000000e-3 RD=5.5000000000e-3 RS=2.0000000000e-3 RG=1.0000000000e-4 RDS=1e9 CGS=1.8300000000e-9 CGDMAX=3.2000000000e-10 CGDMIN=3.2000000000e-10 CJO=1.1000000000e-10 IS=1.0000000000e-12 N=1.5000000000e0 RB=2.0000000000e-3)
