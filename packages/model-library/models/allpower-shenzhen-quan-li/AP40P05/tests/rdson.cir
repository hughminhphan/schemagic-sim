OpenCircuit factory test: AP40P05 RDS(on)
* OpenCircuit Model Factory v0.1.0 bulk adapter
* Original work generated from public factual specifications.
* This model is not copied or adapted from any vendor SPICE model.
* Source: https://jlcpcb.com/api/file/downloadByFileSystemAccessId/8588920859796361216
* Revision: V1.1
.model OC_ALLPOWER-SHENZHEN-QUAN-LI-SEMICONDUCTOR_AP40P05 VDMOS( pchan VTO=-1.6000000000e0 KP=3.0769230769e1 THETA=0.0000000000e0 LAMBDA=3.0000000000e-3 RD=3.5750000000e-2 RS=1.3000000000e-2 RG=1.0000000000e-4 RDS=1e9 CGS=5.2600000000e-10 CGDMAX=7.0000000000e-11 CGDMIN=7.0000000000e-11 CJO=2.0000000000e-11 IS=1.0000000000e-12 N=1.5000000000e0 RB=1.3000000000e-2)

.temp 25
M1 d1 g1 0 OC_ALLPOWER-SHENZHEN-QUAN-LI-SEMICONDUCTOR_AP40P05
ID1 d1 0 DC 3.0000000000e0
VG1 g1 0 DC -1.0000000000e1
M2 d2 g2 0 OC_ALLPOWER-SHENZHEN-QUAN-LI-SEMICONDUCTOR_AP40P05
ID2 d2 0 DC 3.0000000000e0
VG2 g2 0 DC -1.0000000000e1
M3 d3 g3 0 OC_ALLPOWER-SHENZHEN-QUAN-LI-SEMICONDUCTOR_AP40P05
ID3 d3 0 DC 2.0000000000e0
VG3 g3 0 DC -4.5000000000e0
M4 d4 g4 0 OC_ALLPOWER-SHENZHEN-QUAN-LI-SEMICONDUCTOR_AP40P05
ID4 d4 0 DC 2.0000000000e0
VG4 g4 0 DC -4.5000000000e0
.op
.end
