* OpenCircuit Model Factory v0.1.0 bulk adapter
* Original work generated from public factual specifications.
* This model is not copied or adapted from any vendor SPICE model.
* Source: https://jlcpcb.com/api/file/downloadByFileSystemAccessId/8588954565568319489
* Revision: V1.0, 2023/03/17
.model OC_ALLPOWER-SHENZHEN-QUAN-LI-SEMICONDUCTOR_AP3003 VDMOS( VTO=1.0000000000e0 KP=8.3333333333e1 THETA=0.0000000000e0 LAMBDA=3.0000000000e-3 RD=1.3200000000e-2 RS=4.8000000000e-3 RG=1.0000000000e-4 RDS=1e9 CGS=6.4800000000e-10 CGDMAX=5.2000000000e-11 CGDMIN=5.2000000000e-11 CJO=1.4000000000e-11 IS=1.0000000000e-12 N=1.5000000000e0 RB=4.8000000000e-3)
