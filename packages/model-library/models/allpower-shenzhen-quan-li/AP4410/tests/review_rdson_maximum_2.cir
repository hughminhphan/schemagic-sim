OpenCircuit independent review hard-bound probe
* OpenCircuit Model Factory v0.1.0 bulk adapter
* Original work generated from public factual specifications.
* This model is not copied or adapted from any vendor SPICE model.
* Source: https://jlcpcb.com/api/file/downloadByFileSystemAccessId/8588944530314047488
* Revision: V1.1
.model OC_ALLPOWER-SHENZHEN-QUAN-LI-SEMICONDUCTOR_AP4410 VDMOS( VTO=1.5000000000e0 KP=3.0769230769e2 THETA=0.0000000000e0 LAMBDA=3.0000000000e-3 RD=3.5750000000e-3 RS=1.3000000000e-3 RG=1.0000000000e-4 RDS=1e9 CGS=9.6400000000e-10 CGDMAX=1.5200000000e-10 CGDMIN=1.5200000000e-10 CJO=3.5000000000e-11 IS=1.0000000000e-12 N=1.5000000000e0 RB=1.3000000000e-3)
.temp 25
M1 d g 0 OC_ALLPOWER-SHENZHEN-QUAN-LI-SEMICONDUCTOR_AP4410
ID 0 d DC 5.000000000000e+0
VG g 0 DC 4.500000000000e+0
.op
.end
