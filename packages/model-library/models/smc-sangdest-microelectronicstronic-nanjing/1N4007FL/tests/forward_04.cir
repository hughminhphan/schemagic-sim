OpenCircuit factory test: forward_04.cir
* OpenCircuit Model Factory v0.1.0 bulk adapter
* Original work generated from public factual specifications.
* This model is not copied or adapted from any vendor SPICE model.
* Source: https://jlcpcb.com/api/file/downloadByFileSystemAccessId/8588906377209393152
* Revision: Data Sheet N1646, Rev. A
.model OC_SMC-SANGDEST-MICROELECTRONICSTRONIC-NANJING_1N4007FL D(IS=5.8822724915e-6 N=3.1074372621e0 RS=1.4516506957e-2)

.temp 2.5000000000e1
Itest 0 anode PULSE(0 2.0000000000e-1 3.0000000000e-4 3.0000000000e-7 3.0000000000e-7 3.0000000000e-4 3.0000000000e-2)
Vanchor anchor 0 DC 0
Ranchor anchor 0 1G
Ddut anode 0 OC_SMC-SANGDEST-MICROELECTRONICSTRONIC-NANJING_1N4007FL
.tran 7.5000000000e-6 5.2530000000e-4
.end
