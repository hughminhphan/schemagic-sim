* OpenCircuit Model Factory v0.1.0 bulk adapter
* Original work generated from public factual specifications.
* This model is not copied or adapted from any vendor SPICE model.
* Source: https://jlcpcb.com/api/file/downloadByFileSystemAccessId/8603186785955049472
* Revision: Rev:1.0
.model OC_HONGJIACHENG_SS33 D(IS=1.8863333648e-6 N=1.2639209544e0 RS=2.3232533491e-3)
