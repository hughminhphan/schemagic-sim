* OpenCircuit Model Factory v0.1.0 bulk adapter
* Original work generated from public factual specifications.
* This model is not copied or adapted from any vendor SPICE model.
* Source: https://jlcpcb.com/api/file/downloadByFileSystemAccessId/8603186637501313024
* Revision: Rev:1.0
.model OC_HONGJIACHENG_1SS357 D(IS=5.7635926488e-9 N=1.1000000000e0 RS=1.0000000000e-4)
