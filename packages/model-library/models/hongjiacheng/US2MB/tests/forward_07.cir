OpenCircuit factory test: forward_07.cir
* OpenCircuit Model Factory v0.1.0 bulk adapter
* Original work generated from public factual specifications.
* This model is not copied or adapted from any vendor SPICE model.
* Source: https://jlcpcb.com/api/file/downloadByFileSystemAccessId/8602926041484836864
* Revision: Rev. 1.1
.model OC_HONGJIACHENG_US2MB D(IS=8.6788043869e-8 N=3.3214971594e0 RS=1.7408681970e-2)

.temp 25
Itest 0 anode DC 2.0000000000e0
Vanchor anchor 0 DC 0
Ranchor anchor 0 1G
Ddut anode 0 OC_HONGJIACHENG_US2MB
.op
.end
