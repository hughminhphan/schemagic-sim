OpenCircuit factory test: reverse leakage
* OpenCircuit Model Factory v0.1.0 bulk adapter
* Original work generated from public factual specifications.
* This model is not copied or adapted from any vendor SPICE model.
* Source: https://jlcpcb.com/api/file/downloadByFileSystemAccessId/8564879675979173888
* Revision: Rev1.0
.model OC_HONGJIACHENG_1SMA4746A D(IS=2.7707520378e-7 N=2.5845740195e0 RS=2.5802674203e-2 BV=1.8000000000e1 IBV=1.4000000000e-2 NBV=1.0000000000e0)

.temp 25
Vreverse cathode 0 DC 1.3000000000e1
Ddut 0 cathode OC_HONGJIACHENG_1SMA4746A
.op
.end
