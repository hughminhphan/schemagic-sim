OpenCircuit factory test: forward_11.cir
* OpenCircuit Model Factory v0.1.0 bulk adapter
* Original work generated from public factual specifications.
* This model is not copied or adapted from any vendor SPICE model.
* Source: https://jlcpcb.com/api/file/downloadByFileSystemAccessId/8564879404465233920
* Revision: Rev:1.1
.model OC_HONGJIACHENG_MM3Z6V8 D(IS=1.1754976392e-10 N=1.5902596320e0 RS=5.4299825090e-1 BV=6.8000000000e0 IBV=5.0000000000e-3 NBV=1.0000000000e0)

.temp 25
Itest 0 anode DC 2.0000000000e-1
Vanchor anchor 0 DC 0
Ranchor anchor 0 1G
Ddut anode 0 OC_HONGJIACHENG_MM3Z6V8
.op
.end
