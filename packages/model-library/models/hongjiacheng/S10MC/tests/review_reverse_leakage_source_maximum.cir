OpenCircuit independent review hard-bound probe
* OpenCircuit Model Factory v0.1.0 bulk adapter
* Original work generated from public factual specifications.
* This model is not copied or adapted from any vendor SPICE model.
* Source: https://jlcpcb.com/api/file/downloadByFileSystemAccessId/8603067654282358784
* Revision: Rev. 1.1
.model OC_HONGJIACHENG_S10MC D(IS=7.5428796279e-9 N=1.8000000000e0 RS=1.0000000000e-4)
.temp 25
Vreverse cathode 0 DC 1.000000000000e+3
Ddut 0 cathode OC_HONGJIACHENG_S10MC
.op
.end
