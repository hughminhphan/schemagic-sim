* OpenCircuit Model Factory v0.1.0 bulk adapter
* Original work generated from public factual specifications.
* This model is not copied or adapted from any vendor SPICE model.
* Source: https://jlcpcb.com/api/file/downloadByFileSystemAccessId/8564879629501415424
* Revision: Rev:1.0
.model OC_HONGJIACHENG_BZT52C2V7 D(IS=3.9844626533e-11 N=1.8000000000e0 RS=1.0000000000e-4 BV=2.7000000000e0 IBV=5.0000000000e-3 NBV=1.0000000000e0)
