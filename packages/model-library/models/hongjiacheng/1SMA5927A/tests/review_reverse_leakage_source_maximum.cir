OpenCircuit independent review hard-bound probe
* OpenCircuit Model Factory v0.1.0 bulk adapter
* Original work generated from public factual specifications.
* This model is not copied or adapted from any vendor SPICE model.
* Source: https://jlcpcb.com/api/file/downloadByFileSystemAccessId/8564879680836313088
* Revision: Rev: 1.1
.model OC_HONGJIACHENG_1SMA5927A D(IS=4.1235422377e-15 N=1.8000000000e0 RS=1.0000000000e-4 BV=1.2000000000e1 IBV=3.1200000000e-2 NBV=1.0000000000e0)
.temp 25
Vreverse cathode 0 DC 9.100000000000e+0
Ddut 0 cathode OC_HONGJIACHENG_1SMA5927A
.op
.end
