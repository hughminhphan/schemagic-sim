OpenCircuit independent review hard-bound probe
* OpenCircuit Model Factory v0.1.0 bulk adapter
* Original work generated from public factual specifications.
* This model is not copied or adapted from any vendor SPICE model.
* Source: https://jlcpcb.com/api/file/downloadByFileSystemAccessId/8602925402776223744
* Revision: Rev:1.0
.model OC_HONGJIACHENG_SK1045C D(IS=6.2247961947e-8 N=1.1000000000e0 RS=1.0000000000e-4)
.temp 25
Itest 0 anode DC 1.000000000000e+01
Vanchor anchor 0 DC 0
Ranchor anchor 0 1G
Ddut anode 0 OC_HONGJIACHENG_SK1045C
.op
.end
