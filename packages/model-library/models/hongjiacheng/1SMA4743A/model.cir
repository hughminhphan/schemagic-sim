* OpenCircuit Model Factory v0.1.0 bulk adapter
* Original work generated from public factual specifications.
* This model is not copied or adapted from any vendor SPICE model.
* Source: https://jlcpcb.com/api/file/downloadByFileSystemAccessId/8564879674443517952
* Revision: Rev1.0
.model OC_HONGJIACHENG_1SMA4743A D(IS=4.1235422377e-15 N=1.8000000000e0 RS=1.0000000000e-4 BV=1.3000000000e1 IBV=1.9000000000e-2 NBV=1.0000000000e0)
