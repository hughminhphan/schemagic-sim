* OpenCircuit Model Factory v0.1.0 bulk adapter
* Original work generated from public factual specifications.
* This model is not copied or adapted from any vendor SPICE model.
* Source: https://jlcpcb.com/api/file/downloadByFileSystemAccessId/8590905115182112768
* Revision: Rev:1.0
.model OC_HONGJIACHENG_SS34 D(IS=1.5014468505e-8 N=1.1000000000e0 RS=1.0000000000e-4)
