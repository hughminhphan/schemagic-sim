* OpenCircuit Model Factory v0.1.0 bulk adapter
* Original work generated from public factual specifications.
* This model is not copied or adapted from any vendor SPICE model.
* Source: https://jlcpcb.com/api/file/downloadByFileSystemAccessId/8602925630065287168
* Revision: Rev:1.1
.model OC_HONGJIACHENG_ES3DB D(IS=2.2305580393e-9 N=1.8000000000e0 RS=1.0000000000e-4)
