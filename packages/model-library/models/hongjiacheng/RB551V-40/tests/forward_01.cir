OpenCircuit factory test: forward_01.cir
* OpenCircuit Model Factory v0.1.0 bulk adapter
* Original work generated from public factual specifications.
* This model is not copied or adapted from any vendor SPICE model.
* Source: https://jlcpcb.com/api/file/downloadByFileSystemAccessId/8590904985322266624
* Revision: 1.0
.model OC_HONGJIACHENG_RB551V-40 D(IS=4.6956058966e-8 N=1.1000000000e0 RS=1.0000000000e-4)

.temp 25
Itest 0 anode DC 4.7500000000e-1
Vanchor anchor 0 DC 0
Ranchor anchor 0 1G
Ddut anode 0 OC_HONGJIACHENG_RB551V-40
.op
.end
