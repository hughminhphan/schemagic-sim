OpenCircuit independent review hard-bound probe
* OpenCircuit Model Factory v0.1.0 bulk adapter
* Original work generated from public factual specifications.
* This model is not copied or adapted from any vendor SPICE model.
* Source: https://jlcpcb.com/api/file/downloadByFileSystemAccessId/8590904985322266624
* Revision: 1.0
.model OC_HONGJIACHENG_RB551V-40 D(IS=4.6956058966e-8 N=1.1000000000e0 RS=1.0000000000e-4)
.temp 25
Vreverse cathode 0 DC 40.0
Ddut 0 cathode OC_HONGJIACHENG_RB551V-40
.op
.end
