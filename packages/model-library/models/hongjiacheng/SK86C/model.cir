* OpenCircuit Model Factory v0.1.0 bulk adapter
* Original work generated from public factual specifications.
* This model is not copied or adapted from any vendor SPICE model.
* Source: https://jlcpcb.com/api/file/downloadByFileSystemAccessId/8602925945200664576
* Revision: Rev:1.0
.model OC_HONGJIACHENG_SK86C D(IS=2.8735815787e-10 N=1.1000000000e0 RS=1.0000000000e-4)
