OpenCircuit independent review hard-bound probe
* OpenCircuit Model Factory v0.1.0 bulk adapter
* Original work generated from public factual specifications.
* This model is not copied or adapted from any vendor SPICE model.
* Source: https://jlcpcb.com/api/file/downloadByFileSystemAccessId/8590905111176687616
* Revision: Rev:1.0
.model OC_HONGJIACHENG_SS34B D(IS=1.5806475055e-4 N=1.7143740078e0 RS=1.2563782963e-2)
.temp 25
Vreverse cathode 0 DC 4.000000000000e+1
Ddut 0 cathode OC_HONGJIACHENG_SS34B
.op
.end
