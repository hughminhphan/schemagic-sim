OpenCircuit factory test: forward_10.cir
* OpenCircuit Model Factory v0.1.0 bulk adapter
* Original work generated from public factual specifications.
* This model is not copied or adapted from any vendor SPICE model.
* Source: https://jlcpcb.com/api/file/downloadByFileSystemAccessId/8602998422597083136
* Revision: Rev:1.0
.model OC_HONGJIACHENG_BAV99W D(IS=6.5710859546e-10 N=1.7862632021e0 RS=1.1485602562e0)

.temp 25
Itest 0 anode DC 5.0000000000e-2
Vanchor anchor 0 DC 0
Ranchor anchor 0 1G
Ddut anode 0 OC_HONGJIACHENG_BAV99W
.op
.end
