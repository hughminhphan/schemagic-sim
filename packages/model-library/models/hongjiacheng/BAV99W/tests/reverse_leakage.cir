OpenCircuit factory test: reverse leakage
* OpenCircuit Model Factory v0.1.0 bulk adapter
* Original work generated from public factual specifications.
* This model is not copied or adapted from any vendor SPICE model.
* Source: https://jlcpcb.com/api/file/downloadByFileSystemAccessId/8602998422597083136
* Revision: Rev:1.0
.model OC_HONGJIACHENG_BAV99W D(IS=6.5710859546e-10 N=1.7862632021e0 RS=1.1485602562e0)

.temp 25
Vreverse cathode 0 DC 7.5000000000e1
Ddut 0 cathode OC_HONGJIACHENG_BAV99W
.op
.end
