OpenCircuit factory test: forward_09.cir
* OpenCircuit Model Factory v0.1.0 bulk adapter
* Original work generated from public factual specifications.
* This model is not copied or adapted from any vendor SPICE model.
* Source: https://jlcpcb.com/api/file/downloadByFileSystemAccessId/8603005636062306305
* Revision: Rev:1.0
.model OC_HONGJIACHENG_MMBD4148 D(IS=2.9210082566e-7 N=2.8087282555e0 RS=1.6749295423e-1)

.temp 25
Itest 0 anode DC 1.0000000000e-1
Vanchor anchor 0 DC 0
Ranchor anchor 0 1G
Ddut anode 0 OC_HONGJIACHENG_MMBD4148
.op
.end
