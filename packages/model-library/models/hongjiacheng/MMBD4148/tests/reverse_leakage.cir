OpenCircuit factory test: reverse leakage
* OpenCircuit Model Factory v0.1.0 bulk adapter
* Original work generated from public factual specifications.
* This model is not copied or adapted from any vendor SPICE model.
* Source: https://jlcpcb.com/api/file/downloadByFileSystemAccessId/8603005636062306305
* Revision: Rev:1.0
.model OC_HONGJIACHENG_MMBD4148 D(IS=2.9210082566e-7 N=2.8087282555e0 RS=1.6749295423e-1)

.temp 25
Vreverse cathode 0 DC 7.5000000000e1
Ddut 0 cathode OC_HONGJIACHENG_MMBD4148
.op
.end
