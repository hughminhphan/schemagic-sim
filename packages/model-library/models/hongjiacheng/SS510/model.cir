* OpenCircuit Model Factory v0.1.0 bulk adapter
* Original work generated from public factual specifications.
* This model is not copied or adapted from any vendor SPICE model.
* Source: https://jlcpcb.com/api/file/downloadByFileSystemAccessId/8603067511369838592
* Revision: 1.0
.model OC_HONGJIACHENG_SS510 D(IS=1.0328853332e-12 N=1.1000000000e0 RS=1.0000000000e-4)
