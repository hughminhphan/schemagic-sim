OpenCircuit factory test: MMBT4401 supported-region upper-current boundary
* OpenCircuit Model Factory v0.1.0 bulk adapter
* Original work generated from public factual specifications.
* This model is not copied or adapted from any vendor SPICE model.
* Source: https://jlcpcb.com/api/file/downloadByFileSystemAccessId/8603175389229293568
* Revision: Rev:1.0
.model OC_HONGJIACHENG_MMBT4401 NPN(IS=1.0000000000e-14 BF=1.0000000000e2 VAF=1.0000000000e2 IKF=1.0000000000e3 RB=1.0000000000e1 RC=1.0000000000e-1 RE=5.0000000000e-2 CJE=1.0000000000e-12 CJC=1.0000000000e-12 TF=1.0000000000e-9)

.temp 25
IC 0 c DC 5.0000000000e-1
IB 0 b DC 1.2500000000e-2
Q1 c b 0 OC_HONGJIACHENG_MMBT4401
.op
.end
