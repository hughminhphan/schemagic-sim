OpenCircuit factory test: reverse leakage
* OpenCircuit Model Factory v0.1.0 bulk adapter
* Original work generated from public factual specifications.
* This model is not copied or adapted from any vendor SPICE model.
* Source: https://jlcpcb.com/api/file/downloadByFileSystemAccessId/8590910669883449344
* Revision: Rev:1.0
.model OC_HONGJIACHENG_RB501V-40 D(IS=1.4985934208e-7 N=1.0794869703e0 RS=4.5623144327e-1)

.temp 25
Vreverse cathode 0 DC 1.0000000000e1
Ddut 0 cathode OC_HONGJIACHENG_RB501V-40
.op
.end
