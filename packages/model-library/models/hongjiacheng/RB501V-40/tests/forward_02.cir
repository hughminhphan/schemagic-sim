OpenCircuit factory test: forward_02.cir
* OpenCircuit Model Factory v0.1.0 bulk adapter
* Original work generated from public factual specifications.
* This model is not copied or adapted from any vendor SPICE model.
* Source: https://jlcpcb.com/api/file/downloadByFileSystemAccessId/8590910669883449344
* Revision: Rev:1.0
.model OC_HONGJIACHENG_RB501V-40 D(IS=1.4985934208e-7 N=1.0794869703e0 RS=4.5623144327e-1)

.temp 25
Itest 0 anode DC 2.5850000000e-3
Vanchor anchor 0 DC 0
Ranchor anchor 0 1G
Ddut anode 0 OC_HONGJIACHENG_RB501V-40
.op
.end
