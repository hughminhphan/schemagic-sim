* OpenCircuit Model Factory v0.1.0 bulk adapter
* Original work generated from public factual specifications.
* This model is not copied or adapted from any vendor SPICE model.
* Source: https://jlcpcb.com/api/file/downloadByFileSystemAccessId/8603009309819219968
* Revision: Rev:1.0
.model OC_HONGJIACHENG_B0540WS D(IS=3.3265698064e-6 N=1.0594466096e0 RS=1.0384072401e-1)
