OpenCircuit factory test: 2N7002K RDS(on)
* OpenCircuit Model Factory v0.1.0 bulk adapter
* Original work generated from public factual specifications.
* This model is not copied or adapted from any vendor SPICE model.
* Source: https://jlcpcb.com/api/file/downloadByFileSystemAccessId/8564879705364332544
* Revision: Rev:1.0
.model OC_HONGJIACHENG_2N7002K VDMOS( VTO=1.3000000000e0 KP=2.2222222222e0 THETA=0.0000000000e0 LAMBDA=3.0000000000e-3 RD=4.9500000000e-1 RS=1.8000000000e-1 RG=1.0000000000e-4 RDS=1e9 CGS=3.0000000000e-11 CGDMAX=1.0000000000e-11 CGDMIN=1.0000000000e-11 CJO=2.0000000000e-11 IS=1.0000000000e-12 N=1.5000000000e0 RB=1.8000000000e-1)

.temp 25
M1 d1 g1 0 OC_HONGJIACHENG_2N7002K
ID1 0 d1 DC 5.0000000000e-1
VG1 g1 0 DC 1.0000000000e1
M2 d2 g2 0 OC_HONGJIACHENG_2N7002K
ID2 0 d2 DC 5.0000000000e-1
VG2 g2 0 DC 1.0000000000e1
M3 d3 g3 0 OC_HONGJIACHENG_2N7002K
ID3 0 d3 DC 2.0000000000e-1
VG3 g3 0 DC 4.5000000000e0
M4 d4 g4 0 OC_HONGJIACHENG_2N7002K
ID4 0 d4 DC 2.0000000000e-1
VG4 g4 0 DC 4.5000000000e0
.op
.end
