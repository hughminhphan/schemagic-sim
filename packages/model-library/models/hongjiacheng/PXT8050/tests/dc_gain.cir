OpenCircuit factory test: PXT8050 DC gain
* OpenCircuit Model Factory v0.1.0 bulk adapter
* Original work generated from public factual specifications.
* This model is not copied or adapted from any vendor SPICE model.
* Source: https://jlcpcb.com/api/file/downloadByFileSystemAccessId/8564879661869400064
* Revision: Rev:1.1
.model OC_HONGJIACHENG_PXT8050 NPN(IS=1.0000000000e-14 BF=8.5850000000e1 VAF=1.0000000000e2 IKF=1.0000000000e3 RB=1.0000000000e1 RC=1.0000000000e-1 RE=5.0000000000e-2 CJE=1.0000000000e-12 CJC=1.0000000000e-12 TF=1.0000000000e-9)

.temp 25
VCG1 cg1 0 DC 1.0000000000e0
IBG1 0 bg1 DC 1.1764705882e-3
QG1 cg1 bg1 0 OC_HONGJIACHENG_PXT8050
VCG2 cg2 0 DC 1.0000000000e0
IBG2 0 bg2 DC 2.0000000000e-2
QG2 cg2 bg2 0 OC_HONGJIACHENG_PXT8050
.op
.end
