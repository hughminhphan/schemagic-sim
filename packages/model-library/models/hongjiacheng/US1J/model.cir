* OpenCircuit Model Factory v0.1.0 bulk adapter
* Original work generated from public factual specifications.
* This model is not copied or adapted from any vendor SPICE model.
* Source: https://jlcpcb.com/api/file/downloadByFileSystemAccessId/8602925620263333888
* Revision: Rev:1.1
.model OC_HONGJIACHENG_US1J D(IS=1.3422202596e-7 N=3.1344991032e0 RS=2.2902999865e-2)
