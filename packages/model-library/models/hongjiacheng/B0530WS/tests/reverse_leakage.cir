OpenCircuit independent review: published reverse leakage hard bound
* OpenCircuit Model Factory v0.1.0 bulk adapter
* Original work generated from public factual specifications.
* This model is not copied or adapted from any vendor SPICE model.
* Source: https://jlcpcb.com/api/file/downloadByFileSystemAccessId/8602990819196751872
* Revision: Rev:1.0
.model OC_HONGJIACHENG_B0530WS D(IS=4.4203307290e-6 N=1.0955522765e0 RS=8.8135233077e-2)

.temp 25
Vreverse cathode 0 DC 30
Ddut 0 cathode OC_HONGJIACHENG_B0530WS
.op
.end
