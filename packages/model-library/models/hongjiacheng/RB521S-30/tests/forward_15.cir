OpenCircuit factory test: forward_15.cir
* OpenCircuit Model Factory v0.1.0 bulk adapter
* Original work generated from public factual specifications.
* This model is not copied or adapted from any vendor SPICE model.
* Source: https://jlcpcb.com/api/file/downloadByFileSystemAccessId/8603007879490523136
* Revision: Rev:1.0
.model OC_HONGJIACHENG_RB521S-30 D(IS=1.0444065813e-7 N=9.3113852301e-1 RS=3.8781830220e-1)

.temp 25
Itest 0 anode DC 1.0613130000e-2
Vanchor anchor 0 DC 0
Ranchor anchor 0 1G
Ddut anode 0 OC_HONGJIACHENG_RB521S-30
.op
.end
