OpenCircuit factory test: MMBT5401 saturation
* OpenCircuit Model Factory v0.1.0 bulk adapter
* Original work generated from public factual specifications.
* This model is not copied or adapted from any vendor SPICE model.
* Source: https://jlcpcb.com/api/file/downloadByFileSystemAccessId/8590905108882403328
* Revision: Rev:1.0
.model OC_HONGJIACHENG_MMBT5401 PNP(IS=1.0000000000e-14 BF=2.3039122798e2 VAF=1.0000000000e2 IKF=4.7949941973e-1 ISE=6.1111242400e-15 NE=1.5000000000e0 NF=1.0000000000e0 RB=1.0000000000e1 RC=1.0000000000e-1 RE=5.0000000000e-2 CJE=1.0000000000e-12 CJC=1.0000000000e-12 TF=1.0000000000e-9)

.temp 25
ICS1 0 cs1 DC -1.0000000000e-2
IBS1 0 bs1 DC -1.0000000000e-3
QS1 cs1 bs1 0 OC_HONGJIACHENG_MMBT5401
ICS2 0 cs2 DC -5.0000000000e-2
IBS2 0 bs2 DC -5.0000000000e-3
QS2 cs2 bs2 0 OC_HONGJIACHENG_MMBT5401
.op
.end
