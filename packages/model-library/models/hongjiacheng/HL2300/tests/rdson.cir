OpenCircuit factory test: HL2300 RDS(on)
* OpenCircuit Model Factory v0.1.0 bulk adapter
* Original work generated from public factual specifications.
* This model is not copied or adapted from any vendor SPICE model.
* Source: https://jlcpcb.com/api/file/downloadByFileSystemAccessId/8564879623869140992
* Revision: Rev:1.0
.model OC_HONGJIACHENG_HL2300 VDMOS( VTO=6.0000000000e-1 KP=1.0000000000e2 THETA=0.0000000000e0 LAMBDA=3.0000000000e-3 RD=1.1000000000e-2 RS=4.0000000000e-3 RG=1.0000000000e-4 RDS=1e9 CGS=3.4800000000e-10 CGDMAX=7.0000000000e-11 CGDMIN=7.0000000000e-11 CJO=1.2000000000e-11 IS=1.0000000000e-12 N=1.5000000000e0 RB=4.0000000000e-3)

.temp 25
M1 d1 g1 0 OC_HONGJIACHENG_HL2300
ID1 0 d1 DC 4.5000000000e0
VG1 g1 0 DC 4.5000000000e0
M2 d2 g2 0 OC_HONGJIACHENG_HL2300
ID2 0 d2 DC 4.5000000000e0
VG2 g2 0 DC 4.5000000000e0
M3 d3 g3 0 OC_HONGJIACHENG_HL2300
ID3 0 d3 DC 3.0000000000e0
VG3 g3 0 DC 2.5000000000e0
M4 d4 g4 0 OC_HONGJIACHENG_HL2300
ID4 0 d4 DC 3.0000000000e0
VG4 g4 0 DC 2.5000000000e0
M5 d5 g5 0 OC_HONGJIACHENG_HL2300
ID5 0 d5 DC 2.7000000000e0
VG5 g5 0 DC 1.8000000000e0
M6 d6 g6 0 OC_HONGJIACHENG_HL2300
ID6 0 d6 DC 2.7000000000e0
VG6 g6 0 DC 1.8000000000e0
.op
.end
