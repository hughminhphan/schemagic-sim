OpenCircuit factory test: forward_01.cir
* OpenCircuit Model Factory v0.1.0 bulk adapter
* Original work generated from public factual specifications.
* This model is not copied or adapted from any vendor SPICE model.
* Source: https://jlcpcb.com/api/file/downloadByFileSystemAccessId/8603175382677790720
* Revision: Rev:1.0
.model OC_HONGJIACHENG_BAV21WS D(IS=4.6459818801e-11 N=1.8000000000e0 RS=1.0000000000e-4)

.temp 25
Itest 0 anode DC 1.9000000000e-1
Vanchor anchor 0 DC 0
Ranchor anchor 0 1G
Ddut anode 0 OC_HONGJIACHENG_BAV21WS
.op
.end
