OpenCircuit independent review hard-bound probe
* OpenCircuit Model Factory v0.1.0 bulk adapter
* Original work generated from public factual specifications.
* This model is not copied or adapted from any vendor SPICE model.
* Source: https://jlcpcb.com/api/file/downloadByFileSystemAccessId/8603363983772966912
* Revision: Rev:1.0
.model OC_HONGJIACHENG_SS215 D(IS=1.0288902970e-7 N=1.9369431786e0 RS=2.5904500464e-3)
.temp 25
Vreverse cathode 0 DC 1.500000000000e+02
Ddut 0 cathode OC_HONGJIACHENG_SS215
.op
.end
