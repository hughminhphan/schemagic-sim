* OpenCircuit Model Factory v0.1.0 bulk adapter
* Original work generated from public factual specifications.
* This model is not copied or adapted from any vendor SPICE model.
* Source: https://jlcpcb.com/api/file/downloadByFileSystemAccessId/8603186976149823488
* Revision: Rev:1.0
.model OC_HONGJIACHENG_BAT54SW D(IS=1.2557627642e-7 N=1.0838038815e0 RS=9.4470677826e-1)
