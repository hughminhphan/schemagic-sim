OpenCircuit independent review hard-bound probe
* OpenCircuit Model Factory v0.1.0 bulk adapter
* Original work generated from public factual specifications.
* This model is not copied or adapted from any vendor SPICE model.
* Source: https://jlcpcb.com/api/file/downloadByFileSystemAccessId/8590908338140508160
* Revision: Rev:1.0
.model OC_HONGJIACHENG_BAT43WS D(IS=2.3617446404e-16 N=1.1000000000e0 RS=1.0000000000e-4)
.temp 25
Vreverse cathode 0 DC 2.500000000000e+1
Ddut 0 cathode OC_HONGJIACHENG_BAT43WS
.op
.end
