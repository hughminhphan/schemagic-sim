OpenCircuit independent review hard-bound probe
* OpenCircuit Model Factory v0.1.0 bulk adapter
* Original work generated from public factual specifications.
* This model is not copied or adapted from any vendor SPICE model.
* Source: https://jlcpcb.com/api/file/downloadByFileSystemAccessId/8603007658832519168
* Revision: Rev:1.0
.model OC_HONGJIACHENG_1SS226 D(IS=2.3929757691e-10 N=1.4423859266e0 RS=1.4668448372e0)
.temp 25
IZ 0 cathode DC 1.000000000000e-4
Ddut 0 cathode OC_HONGJIACHENG_1SS226
Vall all 0 DC 0
.op
.end
