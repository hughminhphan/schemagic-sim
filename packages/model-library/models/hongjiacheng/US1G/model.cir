* OpenCircuit Model Factory v0.1.0 bulk adapter
* Original work generated from public factual specifications.
* This model is not copied or adapted from any vendor SPICE model.
* Source: https://jlcpcb.com/api/file/downloadByFileSystemAccessId/8602926040482803712
* Revision: Rev:1.1
.model OC_HONGJIACHENG_US1G D(IS=7.4047093317e-10 N=1.8000000000e0 RS=1.0000000000e-4)
