* OpenCircuit Model Factory v0.1.0 bulk adapter
* Original work generated from public factual specifications.
* This model is not copied or adapted from any vendor SPICE model.
* Source: https://jlcpcb.com/api/file/downloadByFileSystemAccessId/8602925639540625408
* Revision: 1.1
.model OC_HONGJIACHENG_ES5JB D(IS=1.5691741023e-15 N=1.8000000000e0 RS=1.0000000000e-4)
