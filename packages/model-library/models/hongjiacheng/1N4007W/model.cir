* OpenCircuit Model Factory v0.1.0 bulk adapter
* Original work generated from public factual specifications.
* This model is not copied or adapted from any vendor SPICE model.
* Source: https://jlcpcb.com/api/file/downloadByFileSystemAccessId/8602925603578257408
* Revision: Rev:1.1
.model OC_HONGJIACHENG_1N4007W D(IS=4.6459818801e-10 N=1.8000000000e0 RS=1.0000000000e-4)
