OpenCircuit factory test: 2SC1623 supported-region upper-current boundary
* OpenCircuit Model Factory v0.1.0 bulk adapter
* Original work generated from public factual specifications.
* This model is not copied or adapted from any vendor SPICE model.
* Source: https://jlcpcb.com/api/file/downloadByFileSystemAccessId/8564879617221033984
* Revision: Rev:1.0
.model OC_HONGJIACHENG_2SC1623 NPN(IS=1.0000000000e-14 BF=3.0940016241e2 VAF=1.0000000000e2 IKF=2.5354766133e-1 RB=1.0000000000e1 RC=1.0000000000e-1 RE=5.0000000000e-2 CJE=1.0000000000e-12 CJC=1.0000000000e-12 TF=1.0000000000e-9)

.temp 25
IC 0 c DC 1.0000000000e-1
IB 0 b DC 4.5454545455e-4
Q1 c b 0 OC_HONGJIACHENG_2SC1623
.op
.end
