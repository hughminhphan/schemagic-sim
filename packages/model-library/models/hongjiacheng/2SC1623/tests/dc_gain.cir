OpenCircuit factory test: 2SC1623 DC gain
* OpenCircuit Model Factory v0.1.0 bulk adapter
* Original work generated from public factual specifications.
* This model is not copied or adapted from any vendor SPICE model.
* Source: https://jlcpcb.com/api/file/downloadByFileSystemAccessId/8564879617221033984
* Revision: Rev:1.0
.model OC_HONGJIACHENG_2SC1623 NPN(IS=1.0000000000e-14 BF=3.0940016241e2 VAF=1.0000000000e2 IKF=2.5354766133e-1 RB=1.0000000000e1 RC=1.0000000000e-1 RE=5.0000000000e-2 CJE=1.0000000000e-12 CJC=1.0000000000e-12 TF=1.0000000000e-9)

.temp 25
VCG1 cg1 0 DC 6.0000000000e0
IBG1 0 bg1 DC 2.9411764706e-7
QG1 cg1 bg1 0 OC_HONGJIACHENG_2SC1623
VCG2 cg2 0 DC 6.0000000000e0
IBG2 0 bg2 DC 3.3333333333e-6
QG2 cg2 bg2 0 OC_HONGJIACHENG_2SC1623
VCG3 cg3 0 DC 6.0000000000e0
IBG3 0 bg3 DC 3.2258064516e-5
QG3 cg3 bg3 0 OC_HONGJIACHENG_2SC1623
VCG4 cg4 0 DC 6.0000000000e0
IBG4 0 bg4 DC 1.6129032258e-4
QG4 cg4 bg4 0 OC_HONGJIACHENG_2SC1623
VCG5 cg5 0 DC 6.0000000000e0
IBG5 0 bg5 DC 4.5454545455e-4
QG5 cg5 bg5 0 OC_HONGJIACHENG_2SC1623
VCG6 cg6 0 DC 6.0000000000e0
IBG6 0 bg6 DC 1.1111111111e-5
QG6 cg6 bg6 0 OC_HONGJIACHENG_2SC1623
VCG7 cg7 0 DC 6.0000000000e0
IBG7 0 bg7 DC 1.6666666667e-6
QG7 cg7 bg7 0 OC_HONGJIACHENG_2SC1623
.op
.end
