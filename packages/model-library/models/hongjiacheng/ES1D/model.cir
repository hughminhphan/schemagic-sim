* OpenCircuit Model Factory v0.1.0 bulk adapter
* Original work generated from public factual specifications.
* This model is not copied or adapted from any vendor SPICE model.
* Source: https://jlcpcb.com/api/file/downloadByFileSystemAccessId/8603067503107194880
* Revision: Rev:1.1
.model OC_HONGJIACHENG_ES1D D(IS=2.3205733254e-7 N=1.8000000000e0 RS=1.0000000000e-4)
