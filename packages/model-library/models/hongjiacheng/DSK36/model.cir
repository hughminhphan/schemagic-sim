* OpenCircuit Model Factory v0.1.0 bulk adapter
* Original work generated from public factual specifications.
* This model is not copied or adapted from any vendor SPICE model.
* Source: https://jlcpcb.com/api/file/downloadByFileSystemAccessId/8603186961897308160
* Revision: Rev:1.0
.model OC_HONGJIACHENG_DSK36 D(IS=3.9840118266e-4 N=2.3811507536e0 RS=2.7741369517e-2)
