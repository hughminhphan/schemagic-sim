OpenCircuit factory test: HL2312 RDS(on)
* OpenCircuit Model Factory v0.1.0 bulk adapter
* Original work generated from public factual specifications.
* This model is not copied or adapted from any vendor SPICE model.
* Source: https://jlcpcb.com/api/file/downloadByFileSystemAccessId/8564879732451147776
* Revision: Rev:1.0
.model OC_HONGJIACHENG_HL2312 VDMOS( VTO=6.2000000000e-1 KP=1.0256410256e2 THETA=0.0000000000e0 LAMBDA=3.0000000000e-3 RD=1.0725000000e-2 RS=3.9000000000e-3 RG=1.0000000000e-4 RDS=1e9 CGS=3.4800000000e-10 CGDMAX=7.0000000000e-11 CGDMIN=7.0000000000e-11 CJO=1.2000000000e-11 IS=1.0000000000e-12 N=1.5000000000e0 RB=3.9000000000e-3)

.temp 25
M1 d1 g1 0 OC_HONGJIACHENG_HL2312
ID1 0 d1 DC 4.5000000000e0
VG1 g1 0 DC 4.5000000000e0
M2 d2 g2 0 OC_HONGJIACHENG_HL2312
ID2 0 d2 DC 3.0000000000e0
VG2 g2 0 DC 2.5000000000e0
M3 d3 g3 0 OC_HONGJIACHENG_HL2312
ID3 0 d3 DC 2.7000000000e0
VG3 g3 0 DC 1.8000000000e0
.op
.end
