OpenCircuit factory test: forward_03.cir
* OpenCircuit Model Factory v0.1.0 bulk adapter
* Original work generated from public factual specifications.
* This model is not copied or adapted from any vendor SPICE model.
* Source: https://jlcpcb.com/api/file/downloadByFileSystemAccessId/8602990811273441280
* Revision: Rev:1.0
.model OC_HONGJIACHENG_BAT60B D(IS=9.1247685273e-7 N=1.1000000000e0 RS=1.0000000000e-4)

.temp 25
Itest 0 anode DC 1.0000000000e0
Vanchor anchor 0 DC 0
Ranchor anchor 0 1G
Ddut anode 0 OC_HONGJIACHENG_BAT60B
.op
.end
