* OpenCircuit Model Factory v0.1.0 bulk adapter
* Original work generated from public factual specifications.
* This model is not copied or adapted from any vendor SPICE model.
* Source: https://jlcpcb.com/api/file/downloadByFileSystemAccessId/8602925618086490112
* Revision: Rev:1.1
.model OC_HONGJIACHENG_S2MF D(IS=7.6840627092e-7 N=2.3631338944e0 RS=2.2564714087e-2)
