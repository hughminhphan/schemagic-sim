OpenCircuit independent review hard-bound probe
* OpenCircuit Model Factory v0.1.0 bulk adapter
* Original work generated from public factual specifications.
* This model is not copied or adapted from any vendor SPICE model.
* Source: https://jlcpcb.com/api/file/downloadByFileSystemAccessId/8603373062914265088
* Revision: Rev. 1.0
.model OC_HONGJIACHENG_DSK320 D(IS=4.2888451329e-5 N=2.4067148746e0 RS=8.4228280935e-3)
.temp 25
Vreverse cathode 0 DC 2.000000000000e+02
Ddut 0 cathode OC_HONGJIACHENG_DSK320
.op
.end
