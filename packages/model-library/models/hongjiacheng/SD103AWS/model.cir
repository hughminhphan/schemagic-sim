* OpenCircuit Model Factory v0.1.0 bulk adapter
* Original work generated from public factual specifications.
* This model is not copied or adapted from any vendor SPICE model.
* Source: https://jlcpcb.com/api/file/downloadByFileSystemAccessId/8590903646676725760
* Revision: Rev:1.0
.model OC_HONGJIACHENG_SD103AWS D(IS=3.9371274800e-7 N=1.1000000000e0 RS=1.0000000000e-4)
