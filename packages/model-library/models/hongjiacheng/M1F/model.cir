* OpenCircuit Model Factory v0.1.0 bulk adapter
* Original work generated from public factual specifications.
* This model is not copied or adapted from any vendor SPICE model.
* Source: https://jlcpcb.com/api/file/downloadByFileSystemAccessId/8602926026712227840
* Revision: Rev.1.1
.model OC_HONGJIACHENG_M1F D(IS=1.0628260791e-6 N=2.6194117644e0 RS=3.4094759767e-2)
