OpenCircuit factory test: forward_02.cir
* OpenCircuit Model Factory v0.1.0 bulk adapter
* Original work generated from public factual specifications.
* This model is not copied or adapted from any vendor SPICE model.
* Source: https://jlcpcb.com/api/file/downloadByFileSystemAccessId/8603186701183700992
* Revision: Rev.1.0
.model OC_HONGJIACHENG_BAS70-06 D(IS=3.7219892306e-7 N=2.3811500623e0 RS=0.0000000000e0)

.temp 25
Itest 0 anode DC 5.0000000000e-5
Vanchor anchor 0 DC 0
Ranchor anchor 0 1G
Ddut anode 0 OC_HONGJIACHENG_BAS70-06
.op
.end
