OpenCircuit factory test: reverse leakage
* OpenCircuit Model Factory v0.1.0 bulk adapter
* Original work generated from public factual specifications.
* This model is not copied or adapted from any vendor SPICE model.
* Source: https://jlcpcb.com/api/file/downloadByFileSystemAccessId/8603186701183700992
* Revision: Rev.1.0
.model OC_HONGJIACHENG_BAS70-06 D(IS=3.7219892306e-7 N=2.3811500623e0 RS=0.0000000000e0)

.temp 25
Vreverse cathode 0 DC 5.0000000000e1
Ddut 0 cathode OC_HONGJIACHENG_BAS70-06
.op
.end
