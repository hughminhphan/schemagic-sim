OpenCircuit factory test: forward_05.cir
* OpenCircuit Model Factory v0.1.0 bulk adapter
* Original work generated from public factual specifications.
* This model is not copied or adapted from any vendor SPICE model.
* Source: https://jlcpcb.com/api/file/downloadByFileSystemAccessId/8590908187099156480
* Revision: Rev. 1.1
.model OC_HONGJIACHENG_US1A D(IS=3.6578946386e-12 N=1.0712823390e0 RS=1.1478938933e-2)

.temp 25
Itest 0 anode DC 1.0000000000e1
Vanchor anchor 0 DC 0
Ranchor anchor 0 1G
Ddut anode 0 OC_HONGJIACHENG_US1A
.op
.end
