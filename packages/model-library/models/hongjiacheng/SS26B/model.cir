* OpenCircuit Model Factory v0.1.0 bulk adapter
* Original work generated from public factual specifications.
* This model is not copied or adapted from any vendor SPICE model.
* Source: https://jlcpcb.com/api/file/downloadByFileSystemAccessId/8602925665608495104
* Revision: Rev:1.0
.model OC_HONGJIACHENG_SS26B D(IS=2.0902405372e-4 N=2.1065438730e0 RS=1.8411005238e-2)
