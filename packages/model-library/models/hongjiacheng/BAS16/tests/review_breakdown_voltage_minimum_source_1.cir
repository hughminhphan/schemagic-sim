OpenCircuit independent review hard-bound probe
* OpenCircuit Model Factory v0.1.0 bulk adapter
* Original work generated from public factual specifications.
* This model is not copied or adapted from any vendor SPICE model.
* Source: https://jlcpcb.com/api/file/downloadByFileSystemAccessId/8603005637479845888
* Revision: Rev:1.0
.model OC_HONGJIACHENG_BAS16 D(IS=1.1656329802e-11 N=1.3131640587e0 RS=1.1184863573e0)
.temp 25
Vanchor anchor 0 DC 0
Ranchor anchor 0 1G
IZ 0 cathode DC 1.000000000000e-04
Ddut 0 cathode OC_HONGJIACHENG_BAS16
.op
.end
