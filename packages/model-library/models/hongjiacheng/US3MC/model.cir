* OpenCircuit Model Factory v0.1.0 bulk adapter
* Original work generated from public factual specifications.
* This model is not copied or adapted from any vendor SPICE model.
* Source: https://jlcpcb.com/api/file/downloadByFileSystemAccessId/8602925629151469568
* Revision: Rev:1.1
.model OC_HONGJIACHENG_US3MC D(IS=5.0625448494e-8 N=2.9747184132e0 RS=7.5615631800e-3)
