OpenCircuit independent review hard-bound probe
* OpenCircuit Model Factory v0.1.0 bulk adapter
* Original work generated from public factual specifications.
* This model is not copied or adapted from any vendor SPICE model.
* Source: https://jlcpcb.com/api/file/downloadByFileSystemAccessId/8603186707466633216
* Revision: Rev:1.0
.model OC_HONGJIACHENG_BAS70W-05 D(IS=6.5472639612e-8 N=1.5402344707e0 RS=3.5075057805e0)
.temp 25
Vanchor anchor 0 DC 0
Ranchor anchor 0 1G
IZ 0 cathode DC 1.000000000000e-05
Ddut 0 cathode OC_HONGJIACHENG_BAS70W-05
.op
.end
