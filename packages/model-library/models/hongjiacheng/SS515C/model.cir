* OpenCircuit Model Factory v0.1.0 bulk adapter
* Original work generated from public factual specifications.
* This model is not copied or adapted from any vendor SPICE model.
* Source: https://jlcpcb.com/api/file/downloadByFileSystemAccessId/8603373070958804992
* Revision: Rev:1.0
.model OC_HONGJIACHENG_SS515C D(IS=7.2261533873e-6 N=2.1432756451e0 RS=4.0487980505e-3)
