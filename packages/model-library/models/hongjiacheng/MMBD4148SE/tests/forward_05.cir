OpenCircuit factory test: forward_05.cir
* OpenCircuit Model Factory v0.1.0 bulk adapter
* Original work generated from public factual specifications.
* This model is not copied or adapted from any vendor SPICE model.
* Source: https://jlcpcb.com/api/file/downloadByFileSystemAccessId/8602890545010528256
* Revision: Rev:1.0
.model OC_HONGJIACHENG_MMBD4148SE D(IS=2.2378996230e-8 N=2.1220266843e0 RS=8.9745550006e-1)

.temp 25
Itest 0 anode DC 8.0000000000e-2
Vanchor anchor 0 DC 0
Ranchor anchor 0 1G
Ddut anode 0 OC_HONGJIACHENG_MMBD4148SE
.op
.end
