* OpenCircuit Model Factory v0.1.0 bulk adapter
* Original work generated from public factual specifications.
* This model is not copied or adapted from any vendor SPICE model.
* Source: https://jlcpcb.com/api/file/downloadByFileSystemAccessId/8564879396168900608
* Revision: 1.1
.model OC_HONGJIACHENG_MMSZ5248B D(IS=3.5339464297e-11 N=1.8000000000e0 RS=1.0000000000e-4 BV=1.8000000000e1 IBV=7.0000000000e-3 NBV=1.0000000000e0)
