* OpenCircuit Model Factory v0.1.0 bulk adapter
* Original work generated from public factual specifications.
* This model is not copied or adapted from any vendor SPICE model.
* Source: https://jlcpcb.com/api/file/downloadByFileSystemAccessId/8564879699135385600
* Revision: Rev:1.0
.model OC_HONGJIACHENG_BZT52C36S D(IS=3.9844626533e-11 N=1.8000000000e0 RS=1.0000000000e-4 BV=3.6000000000e1 IBV=2.0000000000e-3 NBV=1.0000000000e0)
