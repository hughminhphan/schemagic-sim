OpenCircuit factory test: BCX56-10 saturation
* OpenCircuit Model Factory v0.1.0 bulk adapter
* Original work generated from public factual specifications.
* This model is not copied or adapted from any vendor SPICE model.
* Source: https://jlcpcb.com/api/file/downloadByFileSystemAccessId/8564879693661683712
* Revision: Rev:1.1
.model OC_HONGJIACHENG_BCX56-10 NPN(IS=1.0000000000e-14 BF=1.5723171511e2 VAF=1.0000000000e2 IKF=7.4790878196e-1 ISE=2.1543503205e-15 NE=1.5000000000e0 NF=1.0000000000e0 RB=1.0000000000e1 RC=1.0000000000e-1 RE=5.0000000000e-2 CJE=1.0000000000e-12 CJC=1.0000000000e-12 TF=1.0000000000e-9)

.temp 25
ICS1 0 cs1 DC 5.0000000000e-1
IBS1 0 bs1 DC 5.0000000000e-2
QS1 cs1 bs1 0 OC_HONGJIACHENG_BCX56-10
.op
.end
