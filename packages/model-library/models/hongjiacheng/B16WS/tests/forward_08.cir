OpenCircuit factory test: forward_08.cir
* OpenCircuit Model Factory v0.1.0 bulk adapter
* Original work generated from public factual specifications.
* This model is not copied or adapted from any vendor SPICE model.
* Source: https://jlcpcb.com/api/file/downloadByFileSystemAccessId/8590905057779273728
* Revision: Rev:1.0
.model OC_HONGJIACHENG_B16WS D(IS=2.4737393899e-6 N=1.1000000000e0 RS=1.0000000000e-4)

.temp 25
Itest 0 anode DC 5.0000000000e-2
Vanchor anchor 0 DC 0
Ranchor anchor 0 1G
Ddut anode 0 OC_HONGJIACHENG_B16WS
.op
.end
