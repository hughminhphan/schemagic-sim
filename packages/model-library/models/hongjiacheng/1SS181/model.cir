* OpenCircuit Model Factory v0.1.0 bulk adapter
* Original work generated from public factual specifications.
* This model is not copied or adapted from any vendor SPICE model.
* Source: https://jlcpcb.com/api/file/downloadByFileSystemAccessId/8603005811870752768
* Revision: Rev:1.0
.model OC_HONGJIACHENG_1SS181 D(IS=1.8689333051e-9 N=1.8000000000e0 RS=1.0000000000e-4)
