OpenCircuit factory test: forward_04.cir
* OpenCircuit Model Factory v0.1.0 bulk adapter
* Original work generated from public factual specifications.
* This model is not copied or adapted from any vendor SPICE model.
* Source: https://jlcpcb.com/api/file/downloadByFileSystemAccessId/8602925387370545152
* Revision: Rev:1.0
.model OC_HONGJIACHENG_SS520B D(IS=4.9102903739e-6 N=2.2264395050e0 RS=1.9277422435e-2)

.temp 25
Itest 0 anode DC 3.0000000000e-1
Vanchor anchor 0 DC 0
Ranchor anchor 0 1G
Ddut anode 0 OC_HONGJIACHENG_SS520B
.op
.end
