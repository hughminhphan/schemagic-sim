OpenCircuit independent review hard-bound probe
* OpenCircuit Model Factory v0.1.0 bulk adapter
* Original work generated from public factual specifications.
* This model is not copied or adapted from any vendor SPICE model.
* Source: https://jlcpcb.com/api/file/downloadByFileSystemAccessId/8564879461657952256
* Revision: Rev:1.1
.model OC_HONGJIACHENG_MM3Z51 D(IS=6.0191557579e-11 N=1.8000000000e0 RS=1.0000000000e-4 BV=5.1000000000e1 IBV=2.0000000000e-3 NBV=1.0000000000e0)
.temp 25
Itest 0 anode DC 1.000000000000e-02
Vanchor anchor 0 DC 0
Ranchor anchor 0 1G
Ddut anode 0 OC_HONGJIACHENG_MM3Z51
.op
.end
