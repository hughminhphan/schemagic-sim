Batch 9 independent review: MMST5551 exact gain hard bounds
* Public datasheet facts only; no vendor SPICE model used.
.model OC_HONGJIACHENG_MMST5551 NPN(IS=1.0000000000e-14 BF=8.0800000000e1 VAF=1.0000000000e2 IKF=1.0000000000e3 RB=1.0000000000e1 RC=1.0000000000e-1 RE=5.0000000000e-2 CJE=1.0000000000e-12 CJC=1.0000000000e-12 TF=1.0000000000e-9)

.temp 25
VCG1 cg1 0 DC 5
IBG1 0 bg1 DC 1.1861199415761001e-05
QG1 cg1 bg1 0 OC_HONGJIACHENG_MMST5551
VCG2 cg2 0 DC 5
IBG2 0 bg2 DC 0.0001186819000497475
QG2 cg2 bg2 0 OC_HONGJIACHENG_MMST5551
VCG3 cg3 0 DC 5
IBG3 0 bg3 DC 0.00059370207544031533
QG3 cg3 bg3 0 OC_HONGJIACHENG_MMST5551
.op
.end
