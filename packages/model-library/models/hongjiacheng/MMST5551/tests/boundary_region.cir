OpenCircuit factory test: MMST5551 supported-region upper-current boundary
* OpenCircuit Model Factory v0.1.0 bulk adapter
* Original work generated from public factual specifications.
* This model is not copied or adapted from any vendor SPICE model.
* Source: https://jlcpcb.com/api/file/downloadByFileSystemAccessId/8604448564001193984
* Revision: Rev:1.1
.model OC_HONGJIACHENG_MMST5551 NPN(IS=1.0000000000e-14 BF=8.0800000000e1 VAF=1.0000000000e2 IKF=1.0000000000e3 RB=1.0000000000e1 RC=1.0000000000e-1 RE=5.0000000000e-2 CJE=1.0000000000e-12 CJC=1.0000000000e-12 TF=1.0000000000e-9)

.temp 25
IC 0 c DC 5.0000000000e-2
IB 0 b DC 1.6666666667e-3
Q1 c b 0 OC_HONGJIACHENG_MMST5551
.op
.end
