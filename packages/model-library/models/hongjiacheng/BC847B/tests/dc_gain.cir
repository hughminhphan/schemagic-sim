OpenCircuit factory test: BC847B DC gain
* OpenCircuit Model Factory v0.1.0 bulk adapter
* Original work generated from public factual specifications.
* This model is not copied or adapted from any vendor SPICE model.
* Source: https://jlcpcb.com/api/file/downloadByFileSystemAccessId/8564879685864472576
* Revision: Rev:1.0
.model OC_HONGJIACHENG_BC847B NPN(IS=1.0000000000e-14 BF=3.9473236127e2 VAF=1.0000000000e2 IKF=1.7491922007e-1 RB=1.0000000000e1 RC=1.0000000000e-1 RE=5.0000000000e-2 CJE=1.0000000000e-12 CJC=1.0000000000e-12 TF=1.0000000000e-9)

.temp 25
VCG1 cg1 0 DC 5.0000000000e0
IBG1 0 bg1 DC 2.3809523810e-6
QG1 cg1 bg1 0 OC_HONGJIACHENG_BC847B
VCG2 cg2 0 DC 5.0000000000e0
IBG2 0 bg2 DC 4.8780487805e-6
QG2 cg2 bg2 0 OC_HONGJIACHENG_BC847B
VCG3 cg3 0 DC 5.0000000000e0
IBG3 0 bg3 DC 1.2658227848e-5
QG3 cg3 bg3 0 OC_HONGJIACHENG_BC847B
VCG4 cg4 0 DC 5.0000000000e0
IBG4 0 bg4 DC 2.6315789474e-5
QG4 cg4 bg4 0 OC_HONGJIACHENG_BC847B
VCG5 cg5 0 DC 5.0000000000e0
IBG5 0 bg5 DC 5.5555555556e-5
QG5 cg5 bg5 0 OC_HONGJIACHENG_BC847B
VCG6 cg6 0 DC 5.0000000000e0
IBG6 0 bg6 DC 1.4705882353e-4
QG6 cg6 bg6 0 OC_HONGJIACHENG_BC847B
VCG7 cg7 0 DC 5.0000000000e0
IBG7 0 bg7 DC 2.6666666667e-4
QG7 cg7 bg7 0 OC_HONGJIACHENG_BC847B
VCG8 cg8 0 DC 5.0000000000e0
IBG8 0 bg8 DC 4.0000000000e-4
QG8 cg8 bg8 0 OC_HONGJIACHENG_BC847B
VCG9 cg9 0 DC 5.0000000000e0
IBG9 0 bg9 DC 1.0000000000e-5
QG9 cg9 bg9 0 OC_HONGJIACHENG_BC847B
VCG10 cg10 0 DC 5.0000000000e0
IBG10 0 bg10 DC 4.4444444444e-6
QG10 cg10 bg10 0 OC_HONGJIACHENG_BC847B
.op
.end
