OpenCircuit independent review hard-bound probe
* OpenCircuit Model Factory v0.1.0 bulk adapter
* Original work generated from public factual specifications.
* This model is not copied or adapted from any vendor SPICE model.
* Source: https://jlcpcb.com/api/file/downloadByFileSystemAccessId/8602890544998215680
* Revision: Rev:1.0
.model OC_HONGJIACHENG_MMBD4148CC D(IS=1.7322474139e-9 N=1.8000000000e0 RS=1.0000000000e-4)
.temp 25
IZ 0 cathode DC 1.000000000000e-4
Ddut 0 cathode OC_HONGJIACHENG_MMBD4148CC
Vall all 0 DC 0
.op
.end
