* OpenCircuit Model Factory v0.1.0 bulk adapter
* Original work generated from public factual specifications.
* This model is not copied or adapted from any vendor SPICE model.
* Source: https://jlcpcb.com/api/file/downloadByFileSystemAccessId/8603186779961253888
* Revision: Rev:1.0
.model OC_HONGJIACHENG_DSK220 D(IS=1.7459284303e-5 N=2.3377568852e0 RS=1.4817103655e-2)
