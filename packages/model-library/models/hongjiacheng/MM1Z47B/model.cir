* OpenCircuit Model Factory v0.1.0 bulk adapter
* Original work generated from public factual specifications.
* This model is not copied or adapted from any vendor SPICE model.
* Source: https://jlcpcb.com/api/file/downloadByFileSystemAccessId/8564879510144917504
* Revision: Rev:1.0
.model OC_HONGJIACHENG_MM1Z47B D(IS=6.0191557579e-11 N=1.8000000000e0 RS=1.0000000000e-4 BV=4.7000000000e1 IBV=2.5000000000e-3 NBV=1.0000000000e0)
