* OpenCircuit Model Factory v0.1.0 bulk adapter
* Original work generated from public factual specifications.
* This model is not copied or adapted from any vendor SPICE model.
* Source: https://jlcpcb.com/api/file/downloadByFileSystemAccessId/8603186980939583488
* Revision: Rev:1.0
.model OC_HONGJIACHENG_DSK38 D(IS=1.4376105004e-5 N=2.0098118114e0 RS=3.1905480782e-2)
