* OpenCircuit Model Factory v0.1.0 bulk adapter
* Original work generated from public factual specifications.
* This model is not copied or adapted from any vendor SPICE model.
* Source: https://jlcpcb.com/api/file/downloadByFileSystemAccessId/8564879695948120064
* Revision: Rev.1.0
.model OC_HONGJIACHENG_BZT52C24S D(IS=6.0191557579e-11 N=1.8000000000e0 RS=1.0000000000e-4 BV=2.4000000000e1 IBV=5.0000000000e-3 NBV=1.0000000000e0)
