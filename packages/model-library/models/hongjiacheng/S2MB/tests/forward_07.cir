OpenCircuit factory test: forward_07.cir
* OpenCircuit Model Factory v0.1.0 bulk adapter
* Original work generated from public factual specifications.
* This model is not copied or adapted from any vendor SPICE model.
* Source: https://jlcpcb.com/api/file/downloadByFileSystemAccessId/8603067582161707008
* Revision: Rev:1.1
.model OC_HONGJIACHENG_S2MB D(IS=3.0928379832e-4 N=3.9081271100e0 RS=2.9149067964e-2)

.temp 25
Itest 0 anode DC 4.1841100000e0
Vanchor anchor 0 DC 0
Ranchor anchor 0 1G
Ddut anode 0 OC_HONGJIACHENG_S2MB
.op
.end
