* OpenCircuit Model Factory v0.1.0 bulk adapter
* Original work generated from public factual specifications.
* This model is not copied or adapted from any vendor SPICE model.
* Source: https://jlcpcb.com/api/file/downloadByFileSystemAccessId/8603067582161707008
* Revision: Rev:1.1
.model OC_HONGJIACHENG_S2MB D(IS=3.0928379832e-4 N=3.9081271100e0 RS=2.9149067964e-2)
