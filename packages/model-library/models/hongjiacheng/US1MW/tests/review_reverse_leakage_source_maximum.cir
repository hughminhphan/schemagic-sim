OpenCircuit independent review hard-bound probe
* OpenCircuit Model Factory v0.1.0 bulk adapter
* Original work generated from public factual specifications.
* This model is not copied or adapted from any vendor SPICE model.
* Source: https://jlcpcb.com/api/file/downloadByFileSystemAccessId/8603080471161024512
* Revision: Rev:1.0
.model OC_HONGJIACHENG_US1MW D(IS=1.0453399540e-8 N=3.0132054610e0 RS=1.9317252509e-2)
.temp 25
Vreverse cathode 0 DC 1.000000000000e+3
Ddut 0 cathode OC_HONGJIACHENG_US1MW
.op
.end
