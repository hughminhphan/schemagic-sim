OpenCircuit factory test: forward_06.cir
* OpenCircuit Model Factory v0.1.0 bulk adapter
* Original work generated from public factual specifications.
* This model is not copied or adapted from any vendor SPICE model.
* Source: https://jlcpcb.com/api/file/downloadByFileSystemAccessId/8602925648763494400
* Revision: Rev:1.1
.model OC_HONGJIACHENG_ES8JC D(IS=4.6315475528e-11 N=1.7064618176e0 RS=1.1927102592e-2)

.temp 25
Itest 0 anode DC 8.0000000000e0
Vanchor anchor 0 DC 0
Ranchor anchor 0 1G
Ddut anode 0 OC_HONGJIACHENG_ES8JC
.op
.end
