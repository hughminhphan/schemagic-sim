* OpenCircuit Model Factory v0.1.0 bulk adapter
* Original work generated from public factual specifications.
* This model is not copied or adapted from any vendor SPICE model.
* Source: https://jlcpcb.com/api/file/downloadByFileSystemAccessId/8602925648763494400
* Revision: Rev:1.1
.model OC_HONGJIACHENG_ES8JC D(IS=4.6315475528e-11 N=1.7064618176e0 RS=1.1927102592e-2)
