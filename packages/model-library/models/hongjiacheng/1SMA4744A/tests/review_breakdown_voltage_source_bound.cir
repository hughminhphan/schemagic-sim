OpenCircuit independent review hard-bound probe
* OpenCircuit Model Factory v0.1.0 bulk adapter
* Original work generated from public factual specifications.
* This model is not copied or adapted from any vendor SPICE model.
* Source: https://jlcpcb.com/api/file/downloadByFileSystemAccessId/8564879675240841216
* Revision: Rev1.0
.model OC_HONGJIACHENG_1SMA4744A D(IS=4.1235422377e-15 N=1.8000000000e0 RS=1.0000000000e-4 BV=1.5000000000e1 IBV=1.7000000000e-2 NBV=1.0000000000e0)
.temp 25
IZ 0 cathode DC 1.700000000000e-2
Ddut 0 cathode OC_HONGJIACHENG_1SMA4744A
Vall all 0 DC 0
.op
.end
