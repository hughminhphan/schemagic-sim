* OpenCircuit Model Factory v0.1.0 bulk adapter
* Original work generated from public factual specifications.
* This model is not copied or adapted from any vendor SPICE model.
* Source: https://jlcpcb.com/api/file/downloadByFileSystemAccessId/8603186980926730240
* Revision: Rev:1.0
.model OC_HONGJIACHENG_DSK22 D(IS=1.3689174957e-5 N=1.1000000000e0 RS=1.0000000000e-4)
