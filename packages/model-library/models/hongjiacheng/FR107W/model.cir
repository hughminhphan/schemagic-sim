* OpenCircuit Model Factory v0.1.0 bulk adapter
* Original work generated from public factual specifications.
* This model is not copied or adapted from any vendor SPICE model.
* Source: https://jlcpcb.com/api/file/downloadByFileSystemAccessId/8602925619164966912
* Revision: Rev:1.0
.model OC_HONGJIACHENG_FR107W D(IS=2.5407992165e-8 N=1.8000000000e0 RS=1.0000000000e-4)
