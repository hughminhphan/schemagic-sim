OpenCircuit independent review hard-bound probe
* OpenCircuit Model Factory v0.1.0 bulk adapter
* Original work generated from public factual specifications.
* This model is not copied or adapted from any vendor SPICE model.
* Source: https://jlcpcb.com/api/file/downloadByFileSystemAccessId/8603067523324010496
* Revision: Rev:1.0
.model OC_HONGJIACHENG_SS120 D(IS=1.5924050348e-6 N=2.6441730413e0 RS=9.0495675772e-3)
.temp 25
Vreverse cathode 0 DC 2.000000000000e+02
Ddut 0 cathode OC_HONGJIACHENG_SS120
.op
.end
