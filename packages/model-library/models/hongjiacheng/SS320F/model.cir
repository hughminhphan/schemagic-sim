* OpenCircuit Model Factory v0.1.0 bulk adapter
* Original work generated from public factual specifications.
* This model is not copied or adapted from any vendor SPICE model.
* Source: https://jlcpcb.com/api/file/downloadByFileSystemAccessId/8602885746160386048
* Revision: Rev:1.0
.model OC_HONGJIACHENG_SS320F D(IS=2.0510329054e-5 N=2.7006476802e0 RS=1.1859348081e-2)
