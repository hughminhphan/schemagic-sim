* OpenCircuit Model Factory v0.1.0 bulk adapter
* Original work generated from public factual specifications.
* This model is not copied or adapted from any vendor SPICE model.
* Source: https://jlcpcb.com/api/file/downloadByFileSystemAccessId/8602925640601378816
* Revision: Rev:1.1
.model OC_HONGJIACHENG_ES5JBF D(IS=1.5663939340e-8 N=2.7356372974e0 RS=1.8946999857e-2)
