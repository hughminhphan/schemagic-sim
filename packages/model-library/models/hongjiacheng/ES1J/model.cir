* OpenCircuit Model Factory v0.1.0 bulk adapter
* Original work generated from public factual specifications.
* This model is not copied or adapted from any vendor SPICE model.
* Source: https://jlcpcb.com/api/file/downloadByFileSystemAccessId/8603067504013570048
* Revision: Rev:1.1
.model OC_HONGJIACHENG_ES1J D(IS=3.1126666399e-16 N=1.8000000000e0 RS=1.0000000000e-4)
