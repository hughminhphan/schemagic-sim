* OpenCircuit Model Factory v0.1.0 bulk adapter
* Original work generated from public factual specifications.
* This model is not copied or adapted from any vendor SPICE model.
* Source: https://jlcpcb.com/api/file/downloadByFileSystemAccessId/8590905101907681280
* Revision: Rev:1.1
.model OC_HONGJIACHENG_ES2J D(IS=6.2381345229e-16 N=1.8000000000e0 RS=1.0000000000e-4)
