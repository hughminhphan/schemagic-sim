* OpenCircuit Model Factory v0.1.0 bulk adapter
* Original work generated from public factual specifications.
* This model is not copied or adapted from any vendor SPICE model.
* Source: https://jlcpcb.com/api/file/downloadByFileSystemAccessId/8602990867712131072
* Revision: Rev:1.0
.model OC_HONGJIACHENG_1SS400 D(IS=1.1139958033e-12 N=1.8000000000e0 RS=1.0000000000e-4)
