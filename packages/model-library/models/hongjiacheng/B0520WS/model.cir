* OpenCircuit Model Factory v0.1.0 bulk adapter
* Original work generated from public factual specifications.
* This model is not copied or adapted from any vendor SPICE model.
* Source: https://jlcpcb.com/api/file/downloadByFileSystemAccessId/8602990819137626112
* Revision: Rev:1.0
.model OC_HONGJIACHENG_B0520WS D(IS=3.2821406353e-6 N=1.0670613593e0 RS=8.9434407551e-2)
