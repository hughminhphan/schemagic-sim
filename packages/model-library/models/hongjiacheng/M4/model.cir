* OpenCircuit Model Factory v0.1.0 bulk adapter
* Original work generated from public factual specifications.
* This model is not copied or adapted from any vendor SPICE model.
* Source: https://jlcpcb.com/api/file/downloadByFileSystemAccessId/8603080454782132224
* Revision: Rev:1.1
.model OC_HONGJIACHENG_M4 D(IS=7.6877483950e-6 N=3.1265733604e0 RS=3.1712174546e-2)
