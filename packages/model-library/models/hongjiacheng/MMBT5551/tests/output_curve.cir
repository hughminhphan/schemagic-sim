OpenCircuit factory test: MMBT5551 output sanity
* OpenCircuit Model Factory v0.1.0 bulk adapter
* Original work generated from public factual specifications.
* This model is not copied or adapted from any vendor SPICE model.
* Source: https://jlcpcb.com/api/file/downloadByFileSystemAccessId/8590905108798922752
* Revision: Rev:1.0
.model OC_HONGJIACHENG_MMBT5551 NPN(IS=1.0000000000e-14 BF=8.0253032878e2 VAF=1.0000000000e2 IKF=1.7401640803e-2 ISE=1.2541053694e-13 NE=1.5000000000e0 NF=1.0000000000e0 RB=1.0000000000e1 RC=1.0000000000e-1 RE=5.0000000000e-2 CJE=1.0000000000e-12 CJC=1.0000000000e-12 TF=1.0000000000e-9)

.temp 25
VCE1 c1 0 DC 2
IB1 0 b1 DC 0.00001
Q1 c1 b1 0 OC_HONGJIACHENG_MMBT5551
VCE2 c2 0 DC 10
IB2 0 b2 DC 0.00005
Q2 c2 b2 0 OC_HONGJIACHENG_MMBT5551
.op
.end
