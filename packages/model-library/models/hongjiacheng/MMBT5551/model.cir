* OpenCircuit Model Factory v0.1.0 bulk adapter
* Original work generated from public factual specifications.
* This model is not copied or adapted from any vendor SPICE model.
* Source: https://jlcpcb.com/api/file/downloadByFileSystemAccessId/8590905108798922752
* Revision: Rev:1.0
.model OC_HONGJIACHENG_MMBT5551 NPN(IS=1.0000000000e-14 BF=8.0253032878e2 VAF=1.0000000000e2 IKF=1.7401640803e-2 ISE=1.2541053694e-13 NE=1.5000000000e0 NF=1.0000000000e0 RB=1.0000000000e1 RC=1.0000000000e-1 RE=5.0000000000e-2 CJE=1.0000000000e-12 CJC=1.0000000000e-12 TF=1.0000000000e-9)
