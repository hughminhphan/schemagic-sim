* OpenCircuit Model Factory v0.1.0 bulk adapter
* Original work generated from public factual specifications.
* This model is not copied or adapted from any vendor SPICE model.
* Source: https://jlcpcb.com/api/file/downloadByFileSystemAccessId/8564879511792603136
* Revision: Rev. 1.0
.model OC_HONGJIACHENG_HL6042 VDMOS( pchan VTO=-9.0000000000e-1 KP=6.0606060606e1 THETA=0.0000000000e0 LAMBDA=3.0000000000e-3 RD=1.8150000000e-2 RS=6.6000000000e-3 RG=1.0000000000e-4 RDS=1e9 CGS=6.6000000000e-10 CGDMAX=1.0000000000e-10 CGDMIN=1.0000000000e-10 CJO=2.5000000000e-11 IS=1.0000000000e-12 N=1.5000000000e0 RB=6.6000000000e-3)
