OpenCircuit independent review hard-bound probe
* OpenCircuit Model Factory v0.1.0 bulk adapter
* Original work generated from public factual specifications.
* This model is not copied or adapted from any vendor SPICE model.
* Source: https://jlcpcb.com/api/file/downloadByFileSystemAccessId/8602925373495652352
* Revision: Rev:1.1
.model OC_HONGJIACHENG_MURS160 D(IS=1.9376518877e-10 N=2.0639571059e0 RS=1.1828542176e-2)
.temp 25
Vreverse cathode 0 DC 6.000000000000e+02
Ddut 0 cathode OC_HONGJIACHENG_MURS160
.op
.end
