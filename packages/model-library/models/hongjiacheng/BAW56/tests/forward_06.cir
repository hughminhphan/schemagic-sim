OpenCircuit factory test: forward_06.cir
* OpenCircuit Model Factory v0.1.0 bulk adapter
* Original work generated from public factual specifications.
* This model is not copied or adapted from any vendor SPICE model.
* Source: https://jlcpcb.com/api/file/downloadByFileSystemAccessId/8603005810385969152
* Revision: Rev:1.0
.model OC_HONGJIACHENG_BAW56 D(IS=2.5760467228e-9 N=1.7914973723e0 RS=7.9094356518e-1)

.temp 25
Itest 0 anode DC 1.0000000000e-2
Vanchor anchor 0 DC 0
Ranchor anchor 0 1G
Ddut anode 0 OC_HONGJIACHENG_BAW56
.op
.end
