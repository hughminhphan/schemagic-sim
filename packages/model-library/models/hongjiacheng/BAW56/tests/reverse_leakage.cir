OpenCircuit independent review: published reverse leakage hard bound
* OpenCircuit Model Factory v0.1.0 bulk adapter
* Original work generated from public factual specifications.
* This model is not copied or adapted from any vendor SPICE model.
* Source: https://jlcpcb.com/api/file/downloadByFileSystemAccessId/8603005810385969152
* Revision: Rev:1.0
.model OC_HONGJIACHENG_BAW56 D(IS=2.5760467228e-9 N=1.7914973723e0 RS=7.9094356518e-1)

.temp 25
Vreverse cathode 0 DC 70
Ddut 0 cathode OC_HONGJIACHENG_BAW56
.op
.end
