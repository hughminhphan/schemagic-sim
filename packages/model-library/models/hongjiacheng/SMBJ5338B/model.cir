* OpenCircuit Model Factory v0.1.0 bulk adapter
* Original work generated from public factual specifications.
* This model is not copied or adapted from any vendor SPICE model.
* Source: https://jlcpcb.com/api/file/downloadByFileSystemAccessId/8564879084837756928
* Revision: Rev. 1.0
.model OC_HONGJIACHENG_SMBJ5338B D(IS=2.2284493283e-12 N=1.8000000000e0 RS=1.0000000000e-4 BV=5.1000000000e0 IBV=2.4000000000e-1 NBV=1.0000000000e0)
