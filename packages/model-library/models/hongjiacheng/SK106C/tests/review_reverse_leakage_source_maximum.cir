OpenCircuit independent review hard-bound probe
* OpenCircuit Model Factory v0.1.0 bulk adapter
* Original work generated from public factual specifications.
* This model is not copied or adapted from any vendor SPICE model.
* Source: https://jlcpcb.com/api/file/downloadByFileSystemAccessId/8602925401891495936
* Revision: 1.0
.model OC_HONGJIACHENG_SK106C D(IS=3.6162066391e-10 N=1.1000000000e0 RS=1.0000000000e-4)
.temp 25
Vreverse cathode 0 DC 60.0
Ddut 0 cathode OC_HONGJIACHENG_SK106C
.op
.end
