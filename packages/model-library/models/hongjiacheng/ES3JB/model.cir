* OpenCircuit Model Factory v0.1.0 bulk adapter
* Original work generated from public factual specifications.
* This model is not copied or adapted from any vendor SPICE model.
* Source: https://jlcpcb.com/api/file/downloadByFileSystemAccessId/8602925369725378560
* Revision: Rev:1.1
.model OC_HONGJIACHENG_ES3JB D(IS=3.4724923894e-9 N=2.6686040703e0 RS=1.5417870490e-2)
