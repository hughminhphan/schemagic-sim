OpenCircuit factory test: forward_07.cir
* OpenCircuit Model Factory v0.1.0 bulk adapter
* Original work generated from public factual specifications.
* This model is not copied or adapted from any vendor SPICE model.
* Source: https://jlcpcb.com/api/file/downloadByFileSystemAccessId/8603005890978979840
* Revision: Rev:1.0
.model OC_HONGJIACHENG_BAT54A D(IS=2.3588016707e-8 N=1.0250586155e0 RS=1.0727509976e0)

.temp 25
Itest 0 anode DC 1.0000000000e-4
Vanchor anchor 0 DC 0
Ranchor anchor 0 1G
Ddut anode 0 OC_HONGJIACHENG_BAT54A
.op
.end
