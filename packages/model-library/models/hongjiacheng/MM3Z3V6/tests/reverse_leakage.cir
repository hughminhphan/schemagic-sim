OpenCircuit factory test: reverse leakage
* OpenCircuit Model Factory v0.1.0 bulk adapter
* Original work generated from public factual specifications.
* This model is not copied or adapted from any vendor SPICE model.
* Source: https://jlcpcb.com/api/file/downloadByFileSystemAccessId/8564879401302728704
* Revision: Rev:1.1
.model OC_HONGJIACHENG_MM3Z3V6 D(IS=5.2781110461e-11 N=1.5116047007e0 RS=5.2061636367e-1 BV=3.6000000000e0 IBV=5.0000000000e-3 NBV=1.0000000000e0)

.temp 25
Vreverse cathode 0 DC 1.0000000000e0
Ddut 0 cathode OC_HONGJIACHENG_MM3Z3V6
.op
.end
