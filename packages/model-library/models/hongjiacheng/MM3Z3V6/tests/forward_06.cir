OpenCircuit factory test: forward_06.cir
* OpenCircuit Model Factory v0.1.0 bulk adapter
* Original work generated from public factual specifications.
* This model is not copied or adapted from any vendor SPICE model.
* Source: https://jlcpcb.com/api/file/downloadByFileSystemAccessId/8564879401302728704
* Revision: Rev:1.1
.model OC_HONGJIACHENG_MM3Z3V6 D(IS=5.2781110461e-11 N=1.5116047007e0 RS=5.2061636367e-1 BV=3.6000000000e0 IBV=5.0000000000e-3 NBV=1.0000000000e0)

.temp 25
Itest 0 anode DC 2.5000000000e-1
Vanchor anchor 0 DC 0
Ranchor anchor 0 1G
Ddut anode 0 OC_HONGJIACHENG_MM3Z3V6
.op
.end
