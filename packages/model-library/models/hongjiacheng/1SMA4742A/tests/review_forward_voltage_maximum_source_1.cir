OpenCircuit independent review hard-bound probe
* OpenCircuit Model Factory v0.1.0 bulk adapter
* Original work generated from public factual specifications.
* This model is not copied or adapted from any vendor SPICE model.
* Source: https://jlcpcb.com/api/file/downloadByFileSystemAccessId/8564879673646465024
* Revision: 1.0
.model OC_HONGJIACHENG_1SMA4742A D(IS=4.1235422377e-15 N=1.8000000000e0 RS=1.0000000000e-4 BV=1.2000000000e1 IBV=2.1000000000e-2 NBV=1.0000000000e0)
.temp 25
Itest 0 anode DC 0.2
Vanchor anchor 0 DC 0
Ranchor anchor 0 1G
Ddut anode 0 OC_HONGJIACHENG_1SMA4742A
.op
.end
