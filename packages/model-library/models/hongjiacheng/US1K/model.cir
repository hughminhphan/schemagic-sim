* OpenCircuit Model Factory v0.1.0 bulk adapter
* Original work generated from public factual specifications.
* This model is not copied or adapted from any vendor SPICE model.
* Source: https://jlcpcb.com/api/file/downloadByFileSystemAccessId/8602925621081493504
* Revision: Rev:1.1
.model OC_HONGJIACHENG_US1K D(IS=5.9607791842e-10 N=2.6618385764e0 RS=2.1179713771e-2)
