OpenCircuit independent review hard-bound probe
* OpenCircuit Model Factory v0.1.0 bulk adapter
* Original work generated from public factual specifications.
* This model is not copied or adapted from any vendor SPICE model.
* Source: https://jlcpcb.com/api/file/downloadByFileSystemAccessId/8603067493791510528
* Revision: Rev:1.1
.model OC_HONGJIACHENG_ES1G D(IS=1.6878122575e-10 N=1.7742105409e0 RS=1.1690760174e-2)
.temp 25
Vreverse cathode 0 DC 4.000000000000e+02
Ddut 0 cathode OC_HONGJIACHENG_ES1G
.op
.end
