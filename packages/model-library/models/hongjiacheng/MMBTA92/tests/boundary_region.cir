OpenCircuit factory test: MMBTA92 supported-region upper-current boundary
* OpenCircuit Model Factory v0.1.0 bulk adapter
* Original work generated from public factual specifications.
* This model is not copied or adapted from any vendor SPICE model.
* Source: https://jlcpcb.com/api/file/downloadByFileSystemAccessId/8564879428506714112
* Revision: Rev.1.0
.model OC_HONGJIACHENG_MMBTA92 PNP(IS=1.0000000000e-14 BF=1.5525216777e2 VAF=1.0000000000e2 IKF=9.1462851764e-2 ISE=1.2029131198e-14 NE=1.5000000000e0 NF=1.0000000000e0 RB=1.0000000000e1 RC=1.0000000000e-1 RE=5.0000000000e-2 CJE=1.0000000000e-12 CJC=1.0000000000e-12 TF=1.0000000000e-9)

.temp 25
IC 0 c DC -1.5000000000e-1
IB 0 b DC -2.7272727273e-3
Q1 c b 0 OC_HONGJIACHENG_MMBTA92
.op
.end
