OpenCircuit factory test: MMBTA92 DC gain
* OpenCircuit Model Factory v0.1.0 bulk adapter
* Original work generated from public factual specifications.
* This model is not copied or adapted from any vendor SPICE model.
* Source: https://jlcpcb.com/api/file/downloadByFileSystemAccessId/8564879428506714112
* Revision: Rev.1.0
.model OC_HONGJIACHENG_MMBTA92 PNP(IS=1.0000000000e-14 BF=1.5525216777e2 VAF=1.0000000000e2 IKF=9.1462851764e-2 ISE=1.2029131198e-14 NE=1.5000000000e0 NF=1.0000000000e0 RB=1.0000000000e1 RC=1.0000000000e-1 RE=5.0000000000e-2 CJE=1.0000000000e-12 CJC=1.0000000000e-12 TF=1.0000000000e-9)

.temp 25
VCG1 cg1 0 DC -1.0000000000e1
IBG1 0 bg1 DC -6.2500000000e-7
QG1 cg1 bg1 0 OC_HONGJIACHENG_MMBTA92
VCG2 cg2 0 DC -1.0000000000e1
IBG2 0 bg2 DC -6.6666666667e-6
QG2 cg2 bg2 0 OC_HONGJIACHENG_MMBTA92
VCG3 cg3 0 DC -1.0000000000e1
IBG3 0 bg3 DC -6.8965517241e-5
QG3 cg3 bg3 0 OC_HONGJIACHENG_MMBTA92
VCG4 cg4 0 DC -1.0000000000e1
IBG4 0 bg4 DC -2.1428571429e-4
QG4 cg4 bg4 0 OC_HONGJIACHENG_MMBTA92
VCG5 cg5 0 DC -1.0000000000e1
IBG5 0 bg5 DC -5.0000000000e-4
QG5 cg5 bg5 0 OC_HONGJIACHENG_MMBTA92
VCG6 cg6 0 DC -1.0000000000e1
IBG6 0 bg6 DC -1.1111111111e-3
QG6 cg6 bg6 0 OC_HONGJIACHENG_MMBTA92
VCG7 cg7 0 DC -1.0000000000e1
IBG7 0 bg7 DC -2.7272727273e-3
QG7 cg7 bg7 0 OC_HONGJIACHENG_MMBTA92
VCG8 cg8 0 DC -1.0000000000e1
IBG8 0 bg8 DC -1.6666666667e-5
QG8 cg8 bg8 0 OC_HONGJIACHENG_MMBTA92
VCG9 cg9 0 DC -1.0000000000e1
IBG9 0 bg9 DC -1.0000000000e-4
QG9 cg9 bg9 0 OC_HONGJIACHENG_MMBTA92
VCG10 cg10 0 DC -1.0000000000e1
IBG10 0 bg10 DC -3.3333333333e-5
QG10 cg10 bg10 0 OC_HONGJIACHENG_MMBTA92
VCG11 cg11 0 DC -1.0000000000e1
IBG11 0 bg11 DC -5.0000000000e-4
QG11 cg11 bg11 0 OC_HONGJIACHENG_MMBTA92
.op
.end
