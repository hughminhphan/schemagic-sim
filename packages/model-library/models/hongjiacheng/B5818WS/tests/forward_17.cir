OpenCircuit factory test: forward_17.cir
* OpenCircuit Model Factory v0.1.0 bulk adapter
* Original work generated from public factual specifications.
* This model is not copied or adapted from any vendor SPICE model.
* Source: https://jlcpcb.com/api/file/downloadByFileSystemAccessId/8603186697421139968
* Revision: Rev:1.0
.model OC_HONGJIACHENG_B5818WS D(IS=1.5862637990e-6 N=9.9237273840e-1 RS=1.0397921179e-1)

.temp 25
Itest 0 anode DC 2.2711600000e0
Vanchor anchor 0 DC 0
Ranchor anchor 0 1G
Ddut anode 0 OC_HONGJIACHENG_B5818WS
.op
.end
