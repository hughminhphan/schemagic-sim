OpenCircuit independent review hard-bound probe
* OpenCircuit Model Factory v0.1.0 bulk adapter
* Original work generated from public factual specifications.
* This model is not copied or adapted from any vendor SPICE model.
* Source: https://jlcpcb.com/api/file/downloadByFileSystemAccessId/8602926034753249280
* Revision: Rev:1.0
.model OC_HONGJIACHENG_RS1MF D(IS=1.3701739266e-12 N=1.8000000000e0 RS=1.0000000000e-4)
.temp 25
Vreverse cathode 0 DC 1.000000000000e+03
Ddut 0 cathode OC_HONGJIACHENG_RS1MF
.op
.end
