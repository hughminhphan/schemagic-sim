OpenCircuit independent review hard-bound probe
* OpenCircuit Model Factory v0.1.0 bulk adapter
* Original work generated from public factual specifications.
* This model is not copied or adapted from any vendor SPICE model.
* Source: https://jlcpcb.com/api/file/downloadByFileSystemAccessId/8603186707303190528
* Revision: Rev:1.0
.model OC_HONGJIACHENG_B5818W D(IS=6.0392986721e-9 N=1.1000000000e0 RS=1.0000000000e-4)
.temp 25
Vreverse cathode 0 DC 3.000000000000e+1
Ddut 0 cathode OC_HONGJIACHENG_B5818W
.op
.end
