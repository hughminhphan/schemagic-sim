* OpenCircuit Model Factory v0.1.0 bulk adapter
* Original work generated from public factual specifications.
* This model is not copied or adapted from any vendor SPICE model.
* Source: https://jlcpcb.com/api/file/downloadByFileSystemAccessId/8603186707303190528
* Revision: Rev:1.0
.model OC_HONGJIACHENG_B5818W D(IS=6.0392986721e-9 N=1.1000000000e0 RS=1.0000000000e-4)
