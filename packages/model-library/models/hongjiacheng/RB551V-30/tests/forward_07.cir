OpenCircuit factory test: forward_07.cir
* OpenCircuit Model Factory v0.1.0 bulk adapter
* Original work generated from public factual specifications.
* This model is not copied or adapted from any vendor SPICE model.
* Source: https://jlcpcb.com/api/file/downloadByFileSystemAccessId/8602990826671136768
* Revision: Rev:1.0
.model OC_HONGJIACHENG_RB551V-30 D(IS=9.6217781248e-7 N=1.0730258374e0 RS=1.7776597852e-1)

.temp 25
Itest 0 anode DC 2.0000000000e-2
Vanchor anchor 0 DC 0
Ranchor anchor 0 1G
Ddut anode 0 OC_HONGJIACHENG_RB551V-30
.op
.end
