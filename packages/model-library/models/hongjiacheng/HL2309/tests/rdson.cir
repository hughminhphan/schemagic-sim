OpenCircuit factory test: HL2309 RDS(on)
* OpenCircuit Model Factory v0.1.0 bulk adapter
* Original work generated from public factual specifications.
* This model is not copied or adapted from any vendor SPICE model.
* Source: https://jlcpcb.com/api/file/downloadByFileSystemAccessId/8564879728608759808
* Revision: Rev:1.0
.model OC_HONGJIACHENG_HL2309 VDMOS( pchan VTO=-3.0000000000e0 KP=7.2727272727e0 THETA=0.0000000000e0 LAMBDA=3.0000000000e-3 RD=1.5125000000e-1 RS=5.5000000000e-2 RG=1.0000000000e-4 RDS=1e9 CGS=3.7400000000e-10 CGDMAX=6.0000000000e-12 CGDMIN=6.0000000000e-12 CJO=2.6000000000e-11 IS=1.0000000000e-12 N=1.5000000000e0 RB=5.5000000000e-2)

.temp 25
M1 d1 g1 0 OC_HONGJIACHENG_HL2309
ID1 d1 0 DC 1.2500000000e0
VG1 g1 0 DC -1.0000000000e1
M2 d2 g2 0 OC_HONGJIACHENG_HL2309
ID2 d2 0 DC 1.0000000000e0
VG2 g2 0 DC -4.5000000000e0
.op
.end
