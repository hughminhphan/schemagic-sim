OpenCircuit factory test: forward_02.cir
* OpenCircuit Model Factory v0.1.0 bulk adapter
* Original work generated from public factual specifications.
* This model is not copied or adapted from any vendor SPICE model.
* Source: https://jlcpcb.com/api/file/downloadByFileSystemAccessId/8602925638156775424
* Revision: Rev:1.1
.model OC_HONGJIACHENG_US5MC D(IS=1.0550717749e-8 N=2.5011734879e0 RS=2.0674770985e-2)

.temp 25
Itest 0 anode DC 1.0000000000e-1
Vanchor anchor 0 DC 0
Ranchor anchor 0 1G
Ddut anode 0 OC_HONGJIACHENG_US5MC
.op
.end
