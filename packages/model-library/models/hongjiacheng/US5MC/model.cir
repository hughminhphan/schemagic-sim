* OpenCircuit Model Factory v0.1.0 bulk adapter
* Original work generated from public factual specifications.
* This model is not copied or adapted from any vendor SPICE model.
* Source: https://jlcpcb.com/api/file/downloadByFileSystemAccessId/8602925638156775424
* Revision: Rev:1.1
.model OC_HONGJIACHENG_US5MC D(IS=1.0550717749e-8 N=2.5011734879e0 RS=2.0674770985e-2)
