* OpenCircuit Model Factory v0.1.0 bulk adapter
* Original work generated from public factual specifications.
* This model is not copied or adapted from any vendor SPICE model.
* Source: https://jlcpcb.com/api/file/downloadByFileSystemAccessId/8602899685342392320
* Revision: Rev:1.0
.model OC_HONGJIACHENG_US3MBF D(IS=9.3764431341e-16 N=1.8000000000e0 RS=1.0000000000e-4)
