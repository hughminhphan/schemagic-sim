* OpenCircuit Model Factory v0.1.0 bulk adapter
* Original work generated from public factual specifications.
* This model is not copied or adapted from any vendor SPICE model.
* Source: https://jlcpcb.com/api/file/downloadByFileSystemAccessId/8590905050347237376
* Revision: Rev:1.1
.model OC_HONGJIACHENG_US1M D(IS=6.9506293975e-10 N=2.6392500952e0 RS=2.0830191341e-2)
