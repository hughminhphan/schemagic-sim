OpenCircuit independent review hard-bound probe
* OpenCircuit Model Factory v0.1.0 bulk adapter
* Original work generated from public factual specifications.
* This model is not copied or adapted from any vendor SPICE model.
* Source: https://jlcpcb.com/api/file/downloadByFileSystemAccessId/8564879497255280640
* Revision: Rev.1.0
.model OC_HONGJIACHENG_MM1W6V2 D(IS=2.2284493283e-12 N=1.8000000000e0 RS=1.0000000000e-4 BV=6.2000000000e0 IBV=4.1000000000e-2 NBV=1.0000000000e0)
.temp 25
Vreverse cathode 0 DC 3.000000000000e+00
Ddut 0 cathode OC_HONGJIACHENG_MM1W6V2
.op
.end
