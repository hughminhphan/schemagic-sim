OpenCircuit reference: 2N3904-style common-emitter stage
VCC vcc 0 12
VIN drive 0 0.72
RB drive base 10k
RC vcc collector 2k
RE emitter 0 1k
Q1 collector base emitter Q2N3904
.model Q2N3904 NPN(Is=6.734f Xti=3 Eg=1.11 Vaf=74.03 Bf=416.4 Ne=1.259 Ise=6.734f Ikf=66.78m Xtb=1.5 Br=0.7371 Nc=2 Isc=0 Ikr=0 Rc=1 Cjc=3.638p Mjc=0.3085 Vjc=0.75 Fc=0.5 Cje=4.493p Mje=0.2593 Vje=0.75 Tr=239.5n Tf=301.2p Itf=0.4 Vtf=4 Xtf=2 Rb=10)
.op
.end
