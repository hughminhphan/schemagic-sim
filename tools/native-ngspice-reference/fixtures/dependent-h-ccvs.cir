OpenCircuit reference: H current-controlled voltage source
V1 ctrl 0 DC 1
RCTRL ctrl sense 1k
VCS sense 0 DC 0
H1 out 0 VCS 2k
R1 out 0 1k
.op
.end
