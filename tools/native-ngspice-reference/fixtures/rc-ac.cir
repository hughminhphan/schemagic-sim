OpenCircuit reference: RC lowpass AC sweep
V1 in 0 DC 0 AC 1
R1 in out 1k
C1 out 0 1u
.ac dec 20 10 100k
.end
