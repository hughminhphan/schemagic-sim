OpenCircuit reference: underdamped series RLC transient
V1 in 0 PULSE(0 5 0 1u 1u 20m 40m)
R1 in n1 10
L1 n1 out 10m
C1 out 0 1u
.tran 5u 5m
.end
