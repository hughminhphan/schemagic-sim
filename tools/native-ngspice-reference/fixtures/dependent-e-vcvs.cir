OpenCircuit reference: E voltage-controlled voltage source
V1 ctrl 0 DC 1
E1 out 0 ctrl 0 2
R1 out 0 1k
.op
.end
