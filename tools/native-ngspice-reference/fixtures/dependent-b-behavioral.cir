OpenCircuit reference: B typed behavioural voltage source shape
V1 ctrl 0 DC 1.5
B1 out 0 V=(2*abs(v(ctrl)))
R1 out 0 1k
.op
.end
