OpenCircuit reference: LED forward drop operating point
V1 supply 0 DC 5
R1 supply led 330
D1 led 0 DLED
.model DLED D(Is=1e-20 N=2 Rs=0.5 Eg=2.1 Cjo=20p M=0.4 Vj=0.75)
.op
.end
