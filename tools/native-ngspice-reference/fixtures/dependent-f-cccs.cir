OpenCircuit reference: F current-controlled current source
V1 ctrl 0 DC 1
RCTRL ctrl sense 1k
VCS sense 0 DC 0
F1 out 0 VCS 2
R1 out 0 1k
.op
.end
