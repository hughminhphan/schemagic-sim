OpenCircuit reference: coupled-inductor transformer transient
V1 in 0 PULSE(0 5 100u 1u 1u 400u 1m)
RSRC in primary 10
LP primary 0 10m
LS secondary 0 2.5m
K1 LP LS 0.99
RLOAD secondary 0 100
.tran 5u 2m
.end
