OpenCircuit reference: G voltage-controlled current source
V1 ctrl 0 DC 1
G1 out 0 ctrl 0 1m
R1 out 0 1k
.op
.end
