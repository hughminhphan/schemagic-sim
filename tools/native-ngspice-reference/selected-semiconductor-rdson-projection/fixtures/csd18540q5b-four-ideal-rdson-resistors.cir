scheMAGIC CSD18540Q5B ideal reviewed-RDS(on) projection
* four independent ideal 2.2 mOhm resistors; no transistor equation or selected-part device
* reviewed resistance conditions only: TA=25 C, VGS=10 V, ID=28 A
* expected ideal voltage drop per instance: 61.6 mV
.temp 25
R1 d1 0 2.2m
I1 0 d1 DC 28
R2 d2 0 2.2m
I2 0 d2 DC 28
R3 d3 0 2.2m
I3 0 d3 DC 28
R4 d4 0 2.2m
I4 0 d4 DC 28
.op
.end
