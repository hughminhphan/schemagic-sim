scheMAGIC Simulator scenario a09afbbb72d487c1
* scenario-hash a09afbbb72d487c1
Voc_696465616c2d70776d2d7072696d617279 n1 0 PULSE(0 12 0.0000025 2.5e-9 2.5e-9 0.00000104166666667 0.0000025) $ component:ideal-pwm-primary
Roc_6e6f6d696e616c2d6c6f6164 n2 0 25 $ component:nominal-load
Coc_6f75747075742d636170616369746f722d31 n2 0 0.000022 $ component:output-capacitor-1
Coc_6f75747075742d636170616369746f722d32 n2 0 0.000022 $ component:output-capacitor-2
Loc_706f7765722d696e647563746f72 n1 n2 0.00001 $ component:power-inductor
.save all voc_696465616c2d70776d2d7072696d617279#branch @roc_6e6f6d696e616c2d6c6f6164[i] @coc_6f75747075742d636170616369746f722d31[i] @coc_6f75747075742d636170616369746f722d32[i] @loc_706f7765722d696e647563746f72[i]
.tran 2.5e-8 0.00005 0 1.25e-8
.end
