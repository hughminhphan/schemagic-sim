scheMAGIC Simulator scenario e9689ef8811e8aac
* scenario-hash e9689ef8811e8aac
Coc_632d62756c6b n1 0 0.00047 $ component:c-bulk
Coc_632d6c6f63616c n1 0 0.000001 $ component:c-local
Roc_722d6d6f746f722d77696e64696e67 n2 n3 2.4 $ component:r-motor-winding
Roc_732d686967682d6c656674 n1 n2 1m $ component:s-high-left
Roc_732d686967682d7269676874 n1 n4 1G $ component:s-high-right
Roc_732d6c6f772d6c656674 n2 0 1G $ component:s-low-left
Roc_732d6c6f772d7269676874 n4 0 1m $ component:s-low-right
Voc_762d6272696467652d61766572616765 n1 0 DC 9.6 $ component:v-bridge-average
Voc_762d6d6f746f722d6261636b2d656d66 n3 n4 DC 6 $ component:v-motor-back-emf
.save all @coc_632d62756c6b[i] @coc_632d6c6f63616c[i] @roc_722d6d6f746f722d77696e64696e67[i] @roc_732d686967682d6c656674[i] @roc_732d686967682d7269676874[i] @roc_732d6c6f772d6c656674[i] @roc_732d6c6f772d7269676874[i] voc_762d6272696467652d61766572616765#branch voc_762d6d6f746f722d6261636b2d656d66#branch
.op
.end
