scheMAGIC Simulator scenario 38f2bd5e98fd8a37
* scenario-hash 38f2bd5e98fd8a37
.model OC_GENERIC_NMOS NMOS(LEVEL=1 VTO=2 KP=20M LAMBDA=0.02)
Roc_6265686176696f72616c2d6c6f6164 n1 0 1.66666666667 $ component:behavioral-load
Roc_666565646261636b2d6c6f776572 n2 0 10000 $ component:feedback-lower
Roc_666565646261636b2d7570706572 n1 n2 52300 $ component:feedback-upper
Voc_686967682d736964652d676174652d6472697665 n3 n4 PULSE(0 5 0.000002 1e-8 1e-8 3.96666666667e-7 0.000001) $ component:high-side-gate-drive
Moc_686967682d736964652d737769746368 n5 n3 n4 n4 OC_GENERIC_NMOS $ component:high-side-switch
Coc_696e7075742d636170616369746f72 n5 0 0.00001 $ component:input-capacitor
Voc_696e7075742d736f75726365 n5 0 DC 12 $ component:input-source
Voc_6c6f772d736964652d676174652d6472697665 n6 0 PULSE(0 5 0.00000241666666667 1e-8 1e-8 5.63333333333e-7 0.000001) $ component:low-side-gate-drive
Moc_6c6f772d736964652d737769746368 n4 n6 0 0 OC_GENERIC_NMOS $ component:low-side-switch
Coc_6f75747075742d636170616369746f72 n1 0 0.000014 $ component:output-capacitor
Loc_706f7765722d696e647563746f72 n4 n1 0.0000033 $ component:power-inductor
.save all @roc_6265686176696f72616c2d6c6f6164[i] @roc_666565646261636b2d6c6f776572[i] @roc_666565646261636b2d7570706572[i] voc_686967682d736964652d676174652d6472697665#branch @moc_686967682d736964652d737769746368[id] @coc_696e7075742d636170616369746f72[i] voc_696e7075742d736f75726365#branch voc_6c6f772d736964652d676174652d6472697665#branch @moc_6c6f772d736964652d737769746368[id] @coc_6f75747075742d636170616369746f72[i] @loc_706f7765722d696e647563746f72[i]
.tran 1e-8 0.000014 0 2e-8
.end
