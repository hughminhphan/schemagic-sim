OpenCircuit WASM spike: diode-loaded resistor divider
V1 in 0 DC 5
R1 in out 1k
R2 out 0 2k
D1 out 0 DTEST
.model DTEST D(Is=1e-14 N=1)
.op
.end
