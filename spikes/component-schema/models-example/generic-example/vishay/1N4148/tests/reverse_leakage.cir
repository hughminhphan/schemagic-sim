* 1N4148-style PLACEHOLDER reverse leakage test
.include ../model.cir
VREVERSE 0 anode 20
D1 anode 0 OC_1N4148
.op
.print op i(VREVERSE) v(anode)
.end
