* OpenCircuit original-from-facts example model
* 1N4148-style PLACEHOLDER parameters only. Not Phase 3 fitted or validated.
* Pin order for D primitive: anode cathode
.model OC_1N4148 D (
+ IS=4.0e-9 N=1.9 RS=0.6
+ CJO=4.0e-12 VJ=0.75 M=0.33
+ TT=4.0e-9 BV=100 IBV=1.0e-7
+)
