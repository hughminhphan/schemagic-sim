* OpenCircuit original-from-facts example model
* 2N3904 PLACEHOLDER parameters only. Not Phase 3 fitted or validated.
* Pin order for Q primitive: collector base emitter
.model OC_2N3904 NPN (
+ IS=6.7e-15 BF=200 VAF=74
+ CJE=4.5e-12 CJC=3.5e-12
+ TF=3.0e-10 TR=2.0e-8
+ RB=10 RC=1 RE=0.1
+)
